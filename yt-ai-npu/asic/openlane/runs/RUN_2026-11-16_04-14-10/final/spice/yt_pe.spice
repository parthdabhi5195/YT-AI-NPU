* NGSPICE file created from yt_pe.ext - technology: sky130A

* Black-box entry subcircuit for sky130_fd_sc_hd__and2b_1 abstract view
.subckt sky130_fd_sc_hd__and2b_1 A_N B VGND VNB VPB VPWR X
.ends

* Black-box entry subcircuit for sky130_fd_sc_hd__xor2_1 abstract view
.subckt sky130_fd_sc_hd__xor2_1 A B VGND VNB VPB VPWR X
.ends

* Black-box entry subcircuit for sky130_fd_sc_hd__fill_2 abstract view
.subckt sky130_fd_sc_hd__fill_2 VGND VNB VPB VPWR
.ends

* Black-box entry subcircuit for sky130_fd_sc_hd__tapvpwrvgnd_1 abstract view
.subckt sky130_fd_sc_hd__tapvpwrvgnd_1 VGND VPWR
.ends

* Black-box entry subcircuit for sky130_fd_sc_hd__decap_8 abstract view
.subckt sky130_fd_sc_hd__decap_8 VGND VNB VPB VPWR
.ends

* Black-box entry subcircuit for sky130_fd_sc_hd__fill_1 abstract view
.subckt sky130_fd_sc_hd__fill_1 VGND VNB VPB VPWR
.ends

* Black-box entry subcircuit for sky130_fd_sc_hd__dlygate4sd1_1 abstract view
.subckt sky130_fd_sc_hd__dlygate4sd1_1 A VGND VNB VPB VPWR X
.ends

* Black-box entry subcircuit for sky130_fd_sc_hd__nand2_1 abstract view
.subckt sky130_fd_sc_hd__nand2_1 A B VGND VNB VPB VPWR Y
.ends

* Black-box entry subcircuit for sky130_fd_sc_hd__a22o_1 abstract view
.subckt sky130_fd_sc_hd__a22o_1 A1 A2 B1 B2 VGND VNB VPB VPWR X
.ends

* Black-box entry subcircuit for sky130_fd_sc_hd__buf_2 abstract view
.subckt sky130_fd_sc_hd__buf_2 A VGND VNB VPB VPWR X
.ends

* Black-box entry subcircuit for sky130_fd_sc_hd__nor2_1 abstract view
.subckt sky130_fd_sc_hd__nor2_1 A B VGND VNB VPB VPWR Y
.ends

* Black-box entry subcircuit for sky130_fd_sc_hd__clkbuf_2 abstract view
.subckt sky130_fd_sc_hd__clkbuf_2 A VGND VNB VPB VPWR X
.ends

* Black-box entry subcircuit for sky130_fd_sc_hd__clkbuf_4 abstract view
.subckt sky130_fd_sc_hd__clkbuf_4 A VGND VNB VPB VPWR X
.ends

* Black-box entry subcircuit for sky130_fd_sc_hd__decap_6 abstract view
.subckt sky130_fd_sc_hd__decap_6 VGND VNB VPB VPWR
.ends

* Black-box entry subcircuit for sky130_fd_sc_hd__decap_4 abstract view
.subckt sky130_fd_sc_hd__decap_4 VGND VNB VPB VPWR
.ends

* Black-box entry subcircuit for sky130_ef_sc_hd__decap_12 abstract view
.subckt sky130_ef_sc_hd__decap_12 VPWR VGND VPB VNB
.ends

* Black-box entry subcircuit for sky130_fd_sc_hd__dfrtp_1 abstract view
.subckt sky130_fd_sc_hd__dfrtp_1 CLK D RESET_B VGND VNB VPB VPWR Q
.ends

* Black-box entry subcircuit for sky130_fd_sc_hd__and3_1 abstract view
.subckt sky130_fd_sc_hd__and3_1 A B C VGND VNB VPB VPWR X
.ends

* Black-box entry subcircuit for sky130_fd_sc_hd__o211a_1 abstract view
.subckt sky130_fd_sc_hd__o211a_1 A1 A2 B1 C1 VGND VNB VPB VPWR X
.ends

* Black-box entry subcircuit for sky130_fd_sc_hd__inv_2 abstract view
.subckt sky130_fd_sc_hd__inv_2 A VGND VNB VPB VPWR Y
.ends

* Black-box entry subcircuit for sky130_fd_sc_hd__or3_4 abstract view
.subckt sky130_fd_sc_hd__or3_4 A B C VGND VNB VPB VPWR X
.ends

* Black-box entry subcircuit for sky130_fd_sc_hd__xnor2_1 abstract view
.subckt sky130_fd_sc_hd__xnor2_1 A B VGND VNB VPB VPWR Y
.ends

* Black-box entry subcircuit for sky130_fd_sc_hd__o21ai_1 abstract view
.subckt sky130_fd_sc_hd__o21ai_1 A1 A2 B1 VGND VNB VPB VPWR Y
.ends

* Black-box entry subcircuit for sky130_fd_sc_hd__decap_3 abstract view
.subckt sky130_fd_sc_hd__decap_3 VGND VNB VPB VPWR
.ends

* Black-box entry subcircuit for sky130_fd_sc_hd__and2_1 abstract view
.subckt sky130_fd_sc_hd__and2_1 A B VGND VNB VPB VPWR X
.ends

* Black-box entry subcircuit for sky130_fd_sc_hd__a2bb2o_1 abstract view
.subckt sky130_fd_sc_hd__a2bb2o_1 A1_N A2_N B1 B2 VGND VNB VPB VPWR X
.ends

* Black-box entry subcircuit for sky130_fd_sc_hd__nand3_2 abstract view
.subckt sky130_fd_sc_hd__nand3_2 A B C VGND VNB VPB VPWR Y
.ends

* Black-box entry subcircuit for sky130_fd_sc_hd__o21a_1 abstract view
.subckt sky130_fd_sc_hd__o21a_1 A1 A2 B1 VGND VNB VPB VPWR X
.ends

* Black-box entry subcircuit for sky130_fd_sc_hd__a21o_1 abstract view
.subckt sky130_fd_sc_hd__a21o_1 A1 A2 B1 VGND VNB VPB VPWR X
.ends

* Black-box entry subcircuit for sky130_fd_sc_hd__dlygate4sd3_1 abstract view
.subckt sky130_fd_sc_hd__dlygate4sd3_1 A VGND VNB VPB VPWR X
.ends

* Black-box entry subcircuit for sky130_fd_sc_hd__or3_1 abstract view
.subckt sky130_fd_sc_hd__or3_1 A B C VGND VNB VPB VPWR X
.ends

* Black-box entry subcircuit for sky130_fd_sc_hd__a21bo_1 abstract view
.subckt sky130_fd_sc_hd__a21bo_1 A1 A2 B1_N VGND VNB VPB VPWR X
.ends

* Black-box entry subcircuit for sky130_fd_sc_hd__and4_1 abstract view
.subckt sky130_fd_sc_hd__and4_1 A B C D VGND VNB VPB VPWR X
.ends

* Black-box entry subcircuit for sky130_fd_sc_hd__nand3_4 abstract view
.subckt sky130_fd_sc_hd__nand3_4 A B C VGND VNB VPB VPWR Y
.ends

* Black-box entry subcircuit for sky130_fd_sc_hd__buf_1 abstract view
.subckt sky130_fd_sc_hd__buf_1 A VGND VNB VPB VPWR X
.ends

* Black-box entry subcircuit for sky130_fd_sc_hd__dlymetal6s2s_1 abstract view
.subckt sky130_fd_sc_hd__dlymetal6s2s_1 A VGND VNB VPB VPWR X
.ends

* Black-box entry subcircuit for sky130_fd_sc_hd__o21ba_1 abstract view
.subckt sky130_fd_sc_hd__o21ba_1 A1 A2 B1_N VGND VNB VPB VPWR X
.ends

* Black-box entry subcircuit for sky130_fd_sc_hd__nand3_1 abstract view
.subckt sky130_fd_sc_hd__nand3_1 A B C VGND VNB VPB VPWR Y
.ends

* Black-box entry subcircuit for sky130_fd_sc_hd__a31o_1 abstract view
.subckt sky130_fd_sc_hd__a31o_1 A1 A2 A3 B1 VGND VNB VPB VPWR X
.ends

* Black-box entry subcircuit for sky130_fd_sc_hd__nor3_1 abstract view
.subckt sky130_fd_sc_hd__nor3_1 A B C VGND VNB VPB VPWR Y
.ends

* Black-box entry subcircuit for sky130_fd_sc_hd__nand2b_1 abstract view
.subckt sky130_fd_sc_hd__nand2b_1 A_N B VGND VNB VPB VPWR Y
.ends

* Black-box entry subcircuit for sky130_fd_sc_hd__or4_1 abstract view
.subckt sky130_fd_sc_hd__or4_1 A B C D VGND VNB VPB VPWR X
.ends

* Black-box entry subcircuit for sky130_fd_sc_hd__or2_1 abstract view
.subckt sky130_fd_sc_hd__or2_1 A B VGND VNB VPB VPWR X
.ends

* Black-box entry subcircuit for sky130_fd_sc_hd__a211o_1 abstract view
.subckt sky130_fd_sc_hd__a211o_1 A1 A2 B1 C1 VGND VNB VPB VPWR X
.ends

* Black-box entry subcircuit for sky130_fd_sc_hd__a21oi_1 abstract view
.subckt sky130_fd_sc_hd__a21oi_1 A1 A2 B1 VGND VNB VPB VPWR Y
.ends

* Black-box entry subcircuit for sky130_fd_sc_hd__a211oi_2 abstract view
.subckt sky130_fd_sc_hd__a211oi_2 A1 A2 B1 C1 VGND VNB VPB VPWR Y
.ends

* Black-box entry subcircuit for sky130_fd_sc_hd__or4_4 abstract view
.subckt sky130_fd_sc_hd__or4_4 A B C D VGND VNB VPB VPWR X
.ends

* Black-box entry subcircuit for sky130_fd_sc_hd__a22oi_1 abstract view
.subckt sky130_fd_sc_hd__a22oi_1 A1 A2 B1 B2 VGND VNB VPB VPWR Y
.ends

* Black-box entry subcircuit for sky130_fd_sc_hd__and4bb_1 abstract view
.subckt sky130_fd_sc_hd__and4bb_1 A_N B_N C D VGND VNB VPB VPWR X
.ends

* Black-box entry subcircuit for sky130_fd_sc_hd__xnor2_2 abstract view
.subckt sky130_fd_sc_hd__xnor2_2 A B VGND VNB VPB VPWR Y
.ends

* Black-box entry subcircuit for sky130_fd_sc_hd__nand4_1 abstract view
.subckt sky130_fd_sc_hd__nand4_1 A B C D VGND VNB VPB VPWR Y
.ends

* Black-box entry subcircuit for sky130_fd_sc_hd__o211ai_2 abstract view
.subckt sky130_fd_sc_hd__o211ai_2 A1 A2 B1 C1 VGND VNB VPB VPWR Y
.ends

* Black-box entry subcircuit for sky130_fd_sc_hd__buf_6 abstract view
.subckt sky130_fd_sc_hd__buf_6 A VGND VNB VPB VPWR X
.ends

* Black-box entry subcircuit for sky130_fd_sc_hd__nor3b_1 abstract view
.subckt sky130_fd_sc_hd__nor3b_1 A B C_N VGND VNB VPB VPWR Y
.ends

* Black-box entry subcircuit for sky130_fd_sc_hd__a211oi_1 abstract view
.subckt sky130_fd_sc_hd__a211oi_1 A1 A2 B1 C1 VGND VNB VPB VPWR Y
.ends

* Black-box entry subcircuit for sky130_fd_sc_hd__o211ai_1 abstract view
.subckt sky130_fd_sc_hd__o211ai_1 A1 A2 B1 C1 VGND VNB VPB VPWR Y
.ends

* Black-box entry subcircuit for sky130_fd_sc_hd__nand4_2 abstract view
.subckt sky130_fd_sc_hd__nand4_2 A B C D VGND VNB VPB VPWR Y
.ends

* Black-box entry subcircuit for sky130_fd_sc_hd__and3_4 abstract view
.subckt sky130_fd_sc_hd__and3_4 A B C VGND VNB VPB VPWR X
.ends

* Black-box entry subcircuit for sky130_fd_sc_hd__bufinv_16 abstract view
.subckt sky130_fd_sc_hd__bufinv_16 A VGND VNB VPB VPWR Y
.ends

* Black-box entry subcircuit for sky130_fd_sc_hd__xor2_2 abstract view
.subckt sky130_fd_sc_hd__xor2_2 A B VGND VNB VPB VPWR X
.ends

* Black-box entry subcircuit for sky130_fd_sc_hd__a21oi_2 abstract view
.subckt sky130_fd_sc_hd__a21oi_2 A1 A2 B1 VGND VNB VPB VPWR Y
.ends

* Black-box entry subcircuit for sky130_fd_sc_hd__buf_4 abstract view
.subckt sky130_fd_sc_hd__buf_4 A VGND VNB VPB VPWR X
.ends

* Black-box entry subcircuit for sky130_fd_sc_hd__clkbuf_16 abstract view
.subckt sky130_fd_sc_hd__clkbuf_16 A VGND VNB VPB VPWR X
.ends

* Black-box entry subcircuit for sky130_fd_sc_hd__o211ai_4 abstract view
.subckt sky130_fd_sc_hd__o211ai_4 A1 A2 B1 C1 VGND VNB VPB VPWR Y
.ends

* Black-box entry subcircuit for sky130_fd_sc_hd__mux2_1 abstract view
.subckt sky130_fd_sc_hd__mux2_1 A0 A1 S VGND VNB VPB VPWR X
.ends

* Black-box entry subcircuit for sky130_fd_sc_hd__o21ai_2 abstract view
.subckt sky130_fd_sc_hd__o21ai_2 A1 A2 B1 VGND VNB VPB VPWR Y
.ends

* Black-box entry subcircuit for sky130_fd_sc_hd__a211o_4 abstract view
.subckt sky130_fd_sc_hd__a211o_4 A1 A2 B1 C1 VGND VNB VPB VPWR X
.ends

* Black-box entry subcircuit for sky130_fd_sc_hd__buf_8 abstract view
.subckt sky130_fd_sc_hd__buf_8 A VGND VNB VPB VPWR X
.ends

* Black-box entry subcircuit for sky130_fd_sc_hd__clkbuf_1 abstract view
.subckt sky130_fd_sc_hd__clkbuf_1 A VGND VNB VPB VPWR X
.ends

* Black-box entry subcircuit for sky130_fd_sc_hd__and3b_1 abstract view
.subckt sky130_fd_sc_hd__and3b_1 A_N B C VGND VNB VPB VPWR X
.ends

* Black-box entry subcircuit for sky130_fd_sc_hd__or4b_1 abstract view
.subckt sky130_fd_sc_hd__or4b_1 A B C D_N VGND VNB VPB VPWR X
.ends

* Black-box entry subcircuit for sky130_fd_sc_hd__dfrtp_2 abstract view
.subckt sky130_fd_sc_hd__dfrtp_2 CLK D RESET_B VGND VNB VPB VPWR Q
.ends

* Black-box entry subcircuit for sky130_fd_sc_hd__nor3_2 abstract view
.subckt sky130_fd_sc_hd__nor3_2 A B C VGND VNB VPB VPWR Y
.ends

* Black-box entry subcircuit for sky130_fd_sc_hd__o21bai_1 abstract view
.subckt sky130_fd_sc_hd__o21bai_1 A1 A2 B1_N VGND VNB VPB VPWR Y
.ends

* Black-box entry subcircuit for sky130_fd_sc_hd__or3b_1 abstract view
.subckt sky130_fd_sc_hd__or3b_1 A B C_N VGND VNB VPB VPWR X
.ends

* Black-box entry subcircuit for sky130_fd_sc_hd__nor2_2 abstract view
.subckt sky130_fd_sc_hd__nor2_2 A B VGND VNB VPB VPWR Y
.ends

* Black-box entry subcircuit for sky130_fd_sc_hd__o2bb2a_1 abstract view
.subckt sky130_fd_sc_hd__o2bb2a_1 A1_N A2_N B1 B2 VGND VNB VPB VPWR X
.ends

* Black-box entry subcircuit for sky130_fd_sc_hd__nor3_4 abstract view
.subckt sky130_fd_sc_hd__nor3_4 A B C VGND VNB VPB VPWR Y
.ends

* Black-box entry subcircuit for sky130_fd_sc_hd__and2_2 abstract view
.subckt sky130_fd_sc_hd__and2_2 A B VGND VNB VPB VPWR X
.ends

* Black-box entry subcircuit for sky130_fd_sc_hd__or4b_4 abstract view
.subckt sky130_fd_sc_hd__or4b_4 A B C D_N VGND VNB VPB VPWR X
.ends

* Black-box entry subcircuit for sky130_fd_sc_hd__a21boi_2 abstract view
.subckt sky130_fd_sc_hd__a21boi_2 A1 A2 B1_N VGND VNB VPB VPWR Y
.ends

* Black-box entry subcircuit for sky130_fd_sc_hd__a311oi_2 abstract view
.subckt sky130_fd_sc_hd__a311oi_2 A1 A2 A3 B1 C1 VGND VNB VPB VPWR Y
.ends

* Black-box entry subcircuit for sky130_fd_sc_hd__clkinv_4 abstract view
.subckt sky130_fd_sc_hd__clkinv_4 A VGND VNB VPB VPWR Y
.ends

* Black-box entry subcircuit for sky130_fd_sc_hd__buf_12 abstract view
.subckt sky130_fd_sc_hd__buf_12 A VGND VNB VPB VPWR X
.ends

* Black-box entry subcircuit for sky130_fd_sc_hd__o221a_1 abstract view
.subckt sky130_fd_sc_hd__o221a_1 A1 A2 B1 B2 C1 VGND VNB VPB VPWR X
.ends

* Black-box entry subcircuit for sky130_fd_sc_hd__or3b_4 abstract view
.subckt sky130_fd_sc_hd__or3b_4 A B C_N VGND VNB VPB VPWR X
.ends

* Black-box entry subcircuit for sky130_fd_sc_hd__dlymetal6s4s_1 abstract view
.subckt sky130_fd_sc_hd__dlymetal6s4s_1 A VGND VNB VPB VPWR X
.ends

* Black-box entry subcircuit for sky130_fd_sc_hd__or2_4 abstract view
.subckt sky130_fd_sc_hd__or2_4 A B VGND VNB VPB VPWR X
.ends

* Black-box entry subcircuit for sky130_fd_sc_hd__a21boi_1 abstract view
.subckt sky130_fd_sc_hd__a21boi_1 A1 A2 B1_N VGND VNB VPB VPWR Y
.ends

* Black-box entry subcircuit for sky130_fd_sc_hd__o22ai_1 abstract view
.subckt sky130_fd_sc_hd__o22ai_1 A1 A2 B1 B2 VGND VNB VPB VPWR Y
.ends

* Black-box entry subcircuit for sky130_fd_sc_hd__diode_2 abstract view
.subckt sky130_fd_sc_hd__diode_2 DIODE VGND VNB VPB VPWR
.ends

* Black-box entry subcircuit for sky130_fd_sc_hd__nor3b_2 abstract view
.subckt sky130_fd_sc_hd__nor3b_2 A B C_N VGND VNB VPB VPWR Y
.ends

* Black-box entry subcircuit for sky130_fd_sc_hd__o211a_4 abstract view
.subckt sky130_fd_sc_hd__o211a_4 A1 A2 B1 C1 VGND VNB VPB VPWR X
.ends

.subckt yt_pe VGND VPWR a_in[0] a_in[10] a_in[11] a_in[12] a_in[13] a_in[14] a_in[15]
+ a_in[1] a_in[2] a_in[3] a_in[4] a_in[5] a_in[6] a_in[7] a_in[8] a_in[9] a_out[0]
+ a_out[10] a_out[11] a_out[12] a_out[13] a_out[14] a_out[15] a_out[1] a_out[2] a_out[3]
+ a_out[4] a_out[5] a_out[6] a_out[7] a_out[8] a_out[9] acc_out[0] acc_out[10] acc_out[11]
+ acc_out[12] acc_out[13] acc_out[14] acc_out[15] acc_out[16] acc_out[17] acc_out[18]
+ acc_out[19] acc_out[1] acc_out[20] acc_out[21] acc_out[22] acc_out[23] acc_out[24]
+ acc_out[25] acc_out[26] acc_out[27] acc_out[28] acc_out[29] acc_out[2] acc_out[30]
+ acc_out[31] acc_out[3] acc_out[4] acc_out[5] acc_out[6] acc_out[7] acc_out[8] acc_out[9]
+ b_in[0] b_in[1] b_in[2] b_in[3] b_in[4] b_in[5] b_in[6] b_in[7] b_out[0] b_out[1]
+ b_out[2] b_out[3] b_out[4] b_out[5] b_out[6] b_out[7] clear_acc clk en rst_n
X_2037_ _1170_ _1175_ VGND VGND VPWR VPWR _1176_ sky130_fd_sc_hd__and2b_1
X_2106_ _0092_ _0110_ VGND VGND VPWR VPWR _0121_ sky130_fd_sc_hd__xor2_1
XFILLER_10_306 VGND VGND VPWR VPWR sky130_fd_sc_hd__fill_2
XTAP_TAPCELL_ROW_9_159 VGND VPWR sky130_fd_sc_hd__tapvpwrvgnd_1
XFILLER_26_96 VGND VGND VPWR VPWR sky130_fd_sc_hd__decap_8
XFILLER_26_85 VGND VGND VPWR VPWR sky130_fd_sc_hd__fill_1
Xrebuffer7 _0734_ VGND VGND VPWR VPWR net198 sky130_fd_sc_hd__dlygate4sd1_1
XFILLER_36_214 VGND VGND VPWR VPWR sky130_fd_sc_hd__decap_8
X_1270_ _0407_ _0408_ VGND VGND VPWR VPWR _0409_ sky130_fd_sc_hd__nand2_1
X_1606_ net155 net180 net178 net162 VGND VGND VPWR VPWR _0745_ sky130_fd_sc_hd__a22o_1
XFILLER_8_181 VGND VGND VPWR VPWR sky130_fd_sc_hd__fill_1
XTAP_TAPCELL_ROW_14_183 VGND VPWR sky130_fd_sc_hd__tapvpwrvgnd_1
Xfanout149 net150 VGND VGND VPWR VPWR net149 sky130_fd_sc_hd__buf_2
X_1537_ _0674_ _0675_ VGND VGND VPWR VPWR _0676_ sky130_fd_sc_hd__nor2_1
Xfanout127 net6 VGND VGND VPWR VPWR net127 sky130_fd_sc_hd__clkbuf_2
X_1468_ _0605_ _0606_ VGND VGND VPWR VPWR _0607_ sky130_fd_sc_hd__xor2_1
Xfanout105 net109 VGND VGND VPWR VPWR net105 sky130_fd_sc_hd__clkbuf_4
Xfanout138 net139 VGND VGND VPWR VPWR net138 sky130_fd_sc_hd__clkbuf_4
X_1399_ _0537_ _0536_ VGND VGND VPWR VPWR _0538_ sky130_fd_sc_hd__and2b_1
Xfanout116 _0327_ VGND VGND VPWR VPWR net116 sky130_fd_sc_hd__buf_2
XFILLER_27_225 VGND VGND VPWR VPWR sky130_fd_sc_hd__decap_6
XFILLER_18_247 VGND VGND VPWR VPWR sky130_fd_sc_hd__decap_4
XFILLER_18_258 VGND VGND VPWR VPWR sky130_fd_sc_hd__fill_1
XTAP_TAPCELL_ROW_28_264 VGND VPWR sky130_fd_sc_hd__tapvpwrvgnd_1
XFILLER_26_280 VGND VGND VPWR VPWR sky130_fd_sc_hd__decap_8
XFILLER_41_294 VPWR VGND VPWR VGND sky130_ef_sc_hd__decap_12
X_2371_ clknet_2_1__leaf_clk _0011_ net136 VGND VGND VPWR VPWR net46 sky130_fd_sc_hd__dfrtp_1
X_1322_ net173 net123 net59 VGND VGND VPWR VPWR _0461_ sky130_fd_sc_hd__and3_1
X_1253_ net169 net68 net121 net165 VGND VGND VPWR VPWR _0392_ sky130_fd_sc_hd__o211a_1
X_1184_ net176 VGND VGND VPWR VPWR _0323_ sky130_fd_sc_hd__inv_2
XFILLER_24_228 VGND VGND VPWR VPWR sky130_fd_sc_hd__fill_1
XTAP_TAPCELL_ROW_2_121 VGND VPWR sky130_fd_sc_hd__tapvpwrvgnd_1
XTAP_TAPCELL_ROW_25_245 VGND VPWR sky130_fd_sc_hd__tapvpwrvgnd_1
XFILLER_23_250 VGND VGND VPWR VPWR sky130_fd_sc_hd__decap_4
XFILLER_23_42 VGND VGND VPWR VPWR sky130_fd_sc_hd__fill_1
XFILLER_2_154 VGND VGND VPWR VPWR sky130_fd_sc_hd__fill_1
XFILLER_48_83 VGND VGND VPWR VPWR sky130_fd_sc_hd__fill_1
XFILLER_0_57 VGND VGND VPWR VPWR sky130_fd_sc_hd__fill_1
X_1871_ _1008_ _1005_ _1004_ VGND VGND VPWR VPWR _1010_ sky130_fd_sc_hd__or3_4
X_1940_ _1059_ _1076_ VGND VGND VPWR VPWR _1079_ sky130_fd_sc_hd__xnor2_1
XFILLER_14_250 VGND VGND VPWR VPWR sky130_fd_sc_hd__fill_2
X_2285_ _0123_ _0278_ _0122_ VGND VGND VPWR VPWR _0281_ sky130_fd_sc_hd__o21ai_1
XFILLER_29_309 VGND VGND VPWR VPWR sky130_fd_sc_hd__decap_3
X_1236_ net172 net122 net63 VGND VGND VPWR VPWR _0375_ sky130_fd_sc_hd__and3_1
X_2354_ net255 net113 net101 net161 VGND VGND VPWR VPWR _0050_ sky130_fd_sc_hd__a22o_1
X_1305_ _0438_ _0442_ VGND VGND VPWR VPWR _0444_ sky130_fd_sc_hd__xnor2_1
XTAP_TAPCELL_ROW_30_270 VGND VPWR sky130_fd_sc_hd__tapvpwrvgnd_1
XFILLER_20_253 VPWR VGND VPWR VGND sky130_ef_sc_hd__decap_12
XTAP_TAPCELL_ROW_22_226 VGND VPWR sky130_fd_sc_hd__tapvpwrvgnd_1
XPHY_EDGE_ROW_8_Left_58 VGND VGND VPWR VPWR sky130_fd_sc_hd__decap_3
XFILLER_7_257 VGND VGND VPWR VPWR sky130_fd_sc_hd__decap_3
XFILLER_11_286 VGND VGND VPWR VPWR sky130_fd_sc_hd__decap_6
X_2070_ _0083_ _0084_ VGND VGND VPWR VPWR _0085_ sky130_fd_sc_hd__and2_1
XTAP_TAPCELL_ROW_44_351 VGND VPWR sky130_fd_sc_hd__tapvpwrvgnd_1
XTAP_TAPCELL_ROW_36_307 VGND VPWR sky130_fd_sc_hd__tapvpwrvgnd_1
X_1854_ _0955_ _0956_ net164 net188 VGND VGND VPWR VPWR _0993_ sky130_fd_sc_hd__a2bb2o_1
X_1923_ _1057_ _1061_ VGND VGND VPWR VPWR _1062_ sky130_fd_sc_hd__and2_1
X_1785_ _0809_ _0922_ _0923_ VGND VGND VPWR VPWR _0924_ sky130_fd_sc_hd__nand3_2
X_2406_ clknet_2_1__leaf_clk _0046_ net140 VGND VGND VPWR VPWR net33 sky130_fd_sc_hd__dfrtp_1
XFILLER_37_172 VGND VGND VPWR VPWR sky130_fd_sc_hd__fill_1
X_2268_ net49 net112 net100 _0268_ VGND VGND VPWR VPWR _0014_ sky130_fd_sc_hd__a22o_1
X_1219_ _0350_ _0351_ net105 VGND VGND VPWR VPWR _0358_ sky130_fd_sc_hd__o21a_1
X_2337_ net253 net110 net98 net120 VGND VGND VPWR VPWR _0033_ sky130_fd_sc_hd__a22o_1
X_2199_ _0213_ _0455_ _0431_ VGND VGND VPWR VPWR _0214_ sky130_fd_sc_hd__a21o_1
XFILLER_40_315 VGND VGND VPWR VPWR sky130_fd_sc_hd__fill_1
XFILLER_4_205 VGND VGND VPWR VPWR sky130_fd_sc_hd__fill_2
Xhold63 net31 VGND VGND VPWR VPWR net254 sky130_fd_sc_hd__dlygate4sd3_1
Xhold74 net81 VGND VGND VPWR VPWR net265 sky130_fd_sc_hd__dlygate4sd3_1
XFILLER_45_95 VGND VGND VPWR VPWR sky130_fd_sc_hd__fill_1
XFILLER_28_161 VGND VGND VPWR VPWR sky130_fd_sc_hd__decap_3
Xhold85 net66 VGND VGND VPWR VPWR net276 sky130_fd_sc_hd__dlygate4sd3_1
Xhold96 net70 VGND VGND VPWR VPWR net287 sky130_fd_sc_hd__dlygate4sd3_1
XTAP_TAPCELL_ROW_41_332 VGND VPWR sky130_fd_sc_hd__tapvpwrvgnd_1
X_1570_ _0628_ _0704_ _0707_ VGND VGND VPWR VPWR _0709_ sky130_fd_sc_hd__or3_1
XFILLER_6_45 VGND VGND VPWR VPWR sky130_fd_sc_hd__fill_1
XFILLER_3_293 VPWR VGND VPWR VGND sky130_ef_sc_hd__decap_12
X_2053_ _1147_ _1154_ _1153_ VGND VGND VPWR VPWR _0068_ sky130_fd_sc_hd__a21bo_1
X_2122_ _0124_ _0132_ _0136_ VGND VGND VPWR VPWR _0137_ sky130_fd_sc_hd__or3_1
Xrebuffer17 _0793_ VGND VGND VPWR VPWR net208 sky130_fd_sc_hd__dlygate4sd1_1
XFILLER_13_3 VPWR VGND VPWR VGND sky130_ef_sc_hd__decap_12
XFILLER_34_197 VGND VGND VPWR VPWR sky130_fd_sc_hd__decap_4
XFILLER_34_186 VGND VGND VPWR VPWR sky130_fd_sc_hd__fill_2
X_1837_ _0974_ _0975_ VGND VGND VPWR VPWR _0976_ sky130_fd_sc_hd__nor2_1
X_1768_ net151 net147 net117 net189 VGND VGND VPWR VPWR _0907_ sky130_fd_sc_hd__and4_1
X_1906_ _1043_ _1044_ VGND VGND VPWR VPWR _1045_ sky130_fd_sc_hd__and2b_1
X_1699_ _0832_ _0837_ VGND VGND VPWR VPWR _0838_ sky130_fd_sc_hd__and2b_1
XFILLER_40_156 VGND VGND VPWR VPWR sky130_fd_sc_hd__fill_1
Xoutput31 net31 VGND VGND VPWR VPWR a_out[12] sky130_fd_sc_hd__buf_2
Xoutput53 net53 VGND VGND VPWR VPWR acc_out[18] sky130_fd_sc_hd__buf_2
Xoutput75 net75 VGND VGND VPWR VPWR acc_out[9] sky130_fd_sc_hd__buf_2
Xoutput42 net42 VGND VGND VPWR VPWR a_out[8] sky130_fd_sc_hd__buf_2
Xoutput64 net64 VGND VGND VPWR VPWR acc_out[28] sky130_fd_sc_hd__buf_2
XFILLER_48_289 VPWR VGND VPWR VGND sky130_ef_sc_hd__decap_12
XFILLER_48_245 VGND VGND VPWR VPWR sky130_fd_sc_hd__decap_6
X_1622_ _0758_ _0759_ _0760_ VGND VGND VPWR VPWR _0761_ sky130_fd_sc_hd__nand3_4
X_1553_ _0691_ VGND VGND VPWR VPWR _0692_ sky130_fd_sc_hd__inv_2
XFILLER_39_201 VGND VGND VPWR VPWR sky130_fd_sc_hd__decap_8
X_1484_ _0590_ _0622_ VGND VGND VPWR VPWR _0623_ sky130_fd_sc_hd__and2b_1
X_2105_ _0119_ VGND VGND VPWR VPWR _0120_ sky130_fd_sc_hd__inv_2
X_2036_ _1171_ _1174_ VGND VGND VPWR VPWR _1175_ sky130_fd_sc_hd__xnor2_1
XPHY_EDGE_ROW_37_Left_87 VGND VGND VPWR VPWR sky130_fd_sc_hd__decap_3
XFILLER_13_167 VGND VGND VPWR VPWR sky130_fd_sc_hd__fill_1
XFILLER_42_52 VGND VGND VPWR VPWR sky130_fd_sc_hd__decap_3
Xrebuffer8 _0785_ VGND VGND VPWR VPWR net199 sky130_fd_sc_hd__buf_1
XFILLER_3_57 VGND VGND VPWR VPWR sky130_fd_sc_hd__fill_1
XFILLER_3_46 VGND VGND VPWR VPWR sky130_fd_sc_hd__fill_1
XFILLER_44_270 VPWR VGND VPWR VGND sky130_ef_sc_hd__decap_12
XTAP_TAPCELL_ROW_14_184 VGND VPWR sky130_fd_sc_hd__tapvpwrvgnd_1
X_1536_ net163 net156 net129 net128 VGND VGND VPWR VPWR _0675_ sky130_fd_sc_hd__and4_1
X_1605_ net162 net155 net180 net178 VGND VGND VPWR VPWR _0744_ sky130_fd_sc_hd__and4_1
Xfanout128 net6 VGND VGND VPWR VPWR net128 sky130_fd_sc_hd__dlymetal6s2s_1
X_1467_ _0575_ _0577_ VGND VGND VPWR VPWR _0606_ sky130_fd_sc_hd__xnor2_1
Xfanout106 net108 VGND VGND VPWR VPWR net106 sky130_fd_sc_hd__buf_2
X_1398_ net106 _0462_ _0461_ VGND VGND VPWR VPWR _0537_ sky130_fd_sc_hd__o21ba_1
Xfanout139 net140 VGND VGND VPWR VPWR net139 sky130_fd_sc_hd__clkbuf_4
Xfanout117 net9 VGND VGND VPWR VPWR net117 sky130_fd_sc_hd__buf_2
X_2019_ _1155_ _1156_ _1157_ VGND VGND VPWR VPWR _1158_ sky130_fd_sc_hd__nand3_1
XFILLER_35_281 VGND VGND VPWR VPWR sky130_fd_sc_hd__decap_8
XFILLER_35_270 VGND VGND VPWR VPWR sky130_fd_sc_hd__decap_8
XFILLER_10_137 VGND VGND VPWR VPWR sky130_fd_sc_hd__decap_3
XFILLER_41_251 VGND VGND VPWR VPWR sky130_fd_sc_hd__fill_2
XFILLER_45_6 VPWR VGND VPWR VGND sky130_ef_sc_hd__decap_12
X_2370_ clknet_2_1__leaf_clk _0010_ net136 VGND VGND VPWR VPWR net45 sky130_fd_sc_hd__dfrtp_1
X_1252_ net165 net68 _0344_ VGND VGND VPWR VPWR _0391_ sky130_fd_sc_hd__and3_1
X_1321_ _0332_ _0335_ _0459_ net92 VGND VGND VPWR VPWR _0460_ sky130_fd_sc_hd__a31o_1
X_1183_ net186 VGND VGND VPWR VPWR _0322_ sky130_fd_sc_hd__inv_2
XFILLER_17_281 VPWR VGND VPWR VGND sky130_ef_sc_hd__decap_12
XTAP_TAPCELL_ROW_19_210 VGND VPWR sky130_fd_sc_hd__tapvpwrvgnd_1
XFILLER_32_251 VGND VGND VPWR VPWR sky130_fd_sc_hd__fill_1
X_1519_ _0645_ _0656_ _0657_ VGND VGND VPWR VPWR _0658_ sky130_fd_sc_hd__nand3_1
XPHY_EDGE_ROW_12_Right_12 VGND VGND VPWR VPWR sky130_fd_sc_hd__decap_3
XPHY_EDGE_ROW_21_Right_21 VGND VGND VPWR VPWR sky130_fd_sc_hd__decap_3
XTAP_TAPCELL_ROW_33_290 VGND VPWR sky130_fd_sc_hd__tapvpwrvgnd_1
XTAP_TAPCELL_ROW_25_246 VGND VPWR sky130_fd_sc_hd__tapvpwrvgnd_1
XFILLER_23_240 VGND VGND VPWR VPWR sky130_fd_sc_hd__decap_3
XPHY_EDGE_ROW_30_Right_30 VGND VGND VPWR VPWR sky130_fd_sc_hd__decap_3
XFILLER_0_69 VGND VGND VPWR VPWR sky130_fd_sc_hd__fill_1
X_1870_ _1004_ _1005_ _1008_ VGND VGND VPWR VPWR _1009_ sky130_fd_sc_hd__nor3_1
XFILLER_14_284 VGND VGND VPWR VPWR sky130_fd_sc_hd__fill_2
XFILLER_43_3 VPWR VGND VPWR VGND sky130_ef_sc_hd__decap_12
X_2353_ net259 net113 net101 net165 VGND VGND VPWR VPWR _0049_ sky130_fd_sc_hd__a22o_1
XPHY_EDGE_ROW_24_Left_74 VGND VGND VPWR VPWR sky130_fd_sc_hd__decap_3
X_2284_ net284 net115 net103 _0280_ VGND VGND VPWR VPWR _0018_ sky130_fd_sc_hd__a22o_1
X_1235_ _0362_ _0373_ VGND VGND VPWR VPWR _0374_ sky130_fd_sc_hd__nor2_1
X_1304_ _0442_ _0438_ VGND VGND VPWR VPWR _0443_ sky130_fd_sc_hd__and2b_1
XTAP_TAPCELL_ROW_22_227 VGND VPWR sky130_fd_sc_hd__tapvpwrvgnd_1
X_1999_ _1132_ _1137_ VGND VGND VPWR VPWR _1138_ sky130_fd_sc_hd__nand2b_1
XTAP_TAPCELL_ROW_30_271 VGND VPWR sky130_fd_sc_hd__tapvpwrvgnd_1
XFILLER_20_265 VGND VGND VPWR VPWR sky130_fd_sc_hd__decap_4
XFILLER_34_20 VGND VGND VPWR VPWR sky130_fd_sc_hd__decap_8
XFILLER_7_214 VGND VGND VPWR VPWR sky130_fd_sc_hd__decap_8
XFILLER_11_221 VGND VGND VPWR VPWR sky130_fd_sc_hd__decap_3
XFILLER_11_243 VGND VGND VPWR VPWR sky130_fd_sc_hd__decap_3
XTAP_TAPCELL_ROW_36_308 VGND VPWR sky130_fd_sc_hd__tapvpwrvgnd_1
XTAP_TAPCELL_ROW_44_352 VGND VPWR sky130_fd_sc_hd__tapvpwrvgnd_1
X_1922_ _1047_ _1053_ _1056_ VGND VGND VPWR VPWR _1061_ sky130_fd_sc_hd__or3_1
X_1853_ _0319_ _0320_ _0989_ _0990_ VGND VGND VPWR VPWR _0992_ sky130_fd_sc_hd__or4_1
X_1784_ _0895_ _0899_ _0898_ VGND VGND VPWR VPWR _0923_ sky130_fd_sc_hd__a21bo_1
X_2405_ clknet_2_3__leaf_clk _0045_ net140 VGND VGND VPWR VPWR net32 sky130_fd_sc_hd__dfrtp_1
XFILLER_29_118 VGND VGND VPWR VPWR sky130_fd_sc_hd__fill_2
X_2336_ net260 net113 net101 net190 VGND VGND VPWR VPWR _0032_ sky130_fd_sc_hd__a22o_1
XFILLER_37_195 VGND VGND VPWR VPWR sky130_fd_sc_hd__decap_4
X_2267_ net86 _0267_ net90 VGND VGND VPWR VPWR _0268_ sky130_fd_sc_hd__a21o_1
X_1218_ net95 _0355_ VGND VGND VPWR VPWR _0357_ sky130_fd_sc_hd__xor2_1
X_2198_ _0211_ _0208_ _0212_ _0458_ VGND VGND VPWR VPWR _0213_ sky130_fd_sc_hd__a31o_1
XFILLER_4_228 VGND VGND VPWR VPWR sky130_fd_sc_hd__decap_4
Xhold64 net78 VGND VGND VPWR VPWR net255 sky130_fd_sc_hd__dlygate4sd3_1
Xhold75 net39 VGND VGND VPWR VPWR net266 sky130_fd_sc_hd__dlygate4sd3_1
Xhold86 net60 VGND VGND VPWR VPWR net277 sky130_fd_sc_hd__dlygate4sd3_1
XFILLER_45_30 VGND VGND VPWR VPWR sky130_fd_sc_hd__decap_8
XFILLER_28_195 VGND VGND VPWR VPWR sky130_fd_sc_hd__fill_1
XFILLER_28_173 VGND VGND VPWR VPWR sky130_fd_sc_hd__fill_1
XTAP_TAPCELL_ROW_41_333 VGND VPWR sky130_fd_sc_hd__tapvpwrvgnd_1
XFILLER_6_35 VGND VGND VPWR VPWR sky130_fd_sc_hd__fill_1
XFILLER_6_24 VGND VGND VPWR VPWR sky130_fd_sc_hd__decap_4
X_2052_ _0064_ _0065_ _0061_ VGND VGND VPWR VPWR _0067_ sky130_fd_sc_hd__a21o_1
X_2121_ _0134_ _0135_ VGND VGND VPWR VPWR _0136_ sky130_fd_sc_hd__or2_1
XFILLER_34_176 VGND VGND VPWR VPWR sky130_fd_sc_hd__decap_4
X_1905_ _1025_ _1010_ _1039_ _1042_ VGND VGND VPWR VPWR _1044_ sky130_fd_sc_hd__a211o_1
X_1698_ _0833_ _0836_ VGND VGND VPWR VPWR _0837_ sky130_fd_sc_hd__xnor2_1
X_1836_ _0905_ _0973_ _0972_ VGND VGND VPWR VPWR _0975_ sky130_fd_sc_hd__a21oi_1
XPHY_EDGE_ROW_6_Right_6 VGND VGND VPWR VPWR sky130_fd_sc_hd__decap_3
X_1767_ net151 net117 _0886_ _0885_ VGND VGND VPWR VPWR _0906_ sky130_fd_sc_hd__a31o_1
X_2319_ _0186_ _0306_ VGND VGND VPWR VPWR _0307_ sky130_fd_sc_hd__or2_1
XPHY_EDGE_ROW_11_Left_61 VGND VGND VPWR VPWR sky130_fd_sc_hd__decap_3
Xoutput43 net43 VGND VGND VPWR VPWR a_out[9] sky130_fd_sc_hd__buf_2
Xoutput32 net32 VGND VGND VPWR VPWR a_out[13] sky130_fd_sc_hd__buf_2
Xoutput54 net54 VGND VGND VPWR VPWR acc_out[19] sky130_fd_sc_hd__buf_2
Xoutput65 net65 VGND VGND VPWR VPWR acc_out[29] sky130_fd_sc_hd__buf_2
Xoutput76 net76 VGND VGND VPWR VPWR b_out[0] sky130_fd_sc_hd__buf_2
X_1552_ _0688_ _0689_ _0687_ VGND VGND VPWR VPWR _0691_ sky130_fd_sc_hd__o21ba_1
X_1621_ _0756_ _0757_ _0743_ VGND VGND VPWR VPWR _0760_ sky130_fd_sc_hd__a21o_1
X_2104_ _0115_ _0118_ _0109_ _0113_ VGND VGND VPWR VPWR _0119_ sky130_fd_sc_hd__a211oi_2
X_1483_ _0619_ _0621_ _0618_ VGND VGND VPWR VPWR _0622_ sky130_fd_sc_hd__a21o_1
X_2035_ _1172_ _1173_ VGND VGND VPWR VPWR _1174_ sky130_fd_sc_hd__nor2_1
XFILLER_22_124 VGND VGND VPWR VPWR sky130_fd_sc_hd__fill_1
X_1819_ _0319_ _0321_ _0955_ _0956_ VGND VGND VPWR VPWR _0958_ sky130_fd_sc_hd__or4_4
XFILLER_45_249 VGND VGND VPWR VPWR sky130_fd_sc_hd__fill_2
XFILLER_9_106 VGND VGND VPWR VPWR sky130_fd_sc_hd__decap_6
Xrebuffer9 net226 VGND VGND VPWR VPWR net200 sky130_fd_sc_hd__dlygate4sd1_1
XFILLER_3_69 VGND VGND VPWR VPWR sky130_fd_sc_hd__fill_1
XTAP_TAPCELL_ROW_8_150 VGND VPWR sky130_fd_sc_hd__tapvpwrvgnd_1
XFILLER_44_282 VPWR VGND VPWR VGND sky130_ef_sc_hd__decap_12
XTAP_TAPCELL_ROW_14_185 VGND VPWR sky130_fd_sc_hd__tapvpwrvgnd_1
Xfanout129 net5 VGND VGND VPWR VPWR net129 sky130_fd_sc_hd__buf_2
X_1535_ net156 net129 net128 net163 VGND VGND VPWR VPWR _0674_ sky130_fd_sc_hd__a22oi_1
Xfanout107 net108 VGND VGND VPWR VPWR net107 sky130_fd_sc_hd__buf_1
X_1604_ _0740_ _0741_ _0739_ VGND VGND VPWR VPWR _0743_ sky130_fd_sc_hd__a21bo_1
XFILLER_8_194 VGND VGND VPWR VPWR sky130_fd_sc_hd__fill_2
Xfanout118 net9 VGND VGND VPWR VPWR net118 sky130_fd_sc_hd__dlymetal6s2s_1
X_1466_ _0330_ _0599_ _0329_ VGND VGND VPWR VPWR _0605_ sky130_fd_sc_hd__o21ba_1
X_1397_ net105 _0535_ VGND VGND VPWR VPWR _0536_ sky130_fd_sc_hd__xnor2_1
X_2018_ _1105_ _1112_ _1111_ VGND VGND VPWR VPWR _1157_ sky130_fd_sc_hd__a21bo_1
XFILLER_12_34 VPWR VGND VPWR VGND sky130_ef_sc_hd__decap_12
XFILLER_37_53 VGND VGND VPWR VPWR sky130_fd_sc_hd__decap_3
XFILLER_37_31 VPWR VGND VPWR VGND sky130_ef_sc_hd__decap_12
XFILLER_41_285 VGND VGND VPWR VPWR sky130_fd_sc_hd__fill_1
XTAP_TAPCELL_ROW_11_166 VGND VPWR sky130_fd_sc_hd__tapvpwrvgnd_1
X_1320_ net127 net141 VGND VGND VPWR VPWR _0459_ sky130_fd_sc_hd__and2b_1
X_1182_ net188 VGND VGND VPWR VPWR _0321_ sky130_fd_sc_hd__inv_2
X_1251_ net92 _0389_ VGND VGND VPWR VPWR _0390_ sky130_fd_sc_hd__and2_1
XTAP_TAPCELL_ROW_19_211 VGND VPWR sky130_fd_sc_hd__tapvpwrvgnd_1
XFILLER_32_263 VPWR VGND VPWR VGND sky130_ef_sc_hd__decap_12
X_1518_ _0602_ _0631_ _0644_ VGND VGND VPWR VPWR _0657_ sky130_fd_sc_hd__a21o_1
X_1449_ _0557_ _0587_ VGND VGND VPWR VPWR _0588_ sky130_fd_sc_hd__xor2_1
XTAP_TAPCELL_ROW_33_291 VGND VPWR sky130_fd_sc_hd__tapvpwrvgnd_1
XTAP_TAPCELL_ROW_25_247 VGND VPWR sky130_fd_sc_hd__tapvpwrvgnd_1
XFILLER_3_3 VPWR VGND VPWR VGND sky130_ef_sc_hd__decap_12
XFILLER_48_85 VGND VGND VPWR VPWR sky130_fd_sc_hd__decap_6
XFILLER_48_41 VPWR VGND VPWR VGND sky130_ef_sc_hd__decap_12
XFILLER_0_15 VGND VGND VPWR VPWR sky130_fd_sc_hd__fill_2
XFILLER_0_37 VGND VGND VPWR VPWR sky130_fd_sc_hd__fill_1
XFILLER_9_57 VGND VGND VPWR VPWR sky130_fd_sc_hd__fill_1
X_2283_ net86 _0279_ net90 VGND VGND VPWR VPWR _0280_ sky130_fd_sc_hd__a21o_1
XFILLER_36_3 VGND VGND VPWR VPWR sky130_fd_sc_hd__fill_1
X_1303_ net105 _0440_ _0439_ VGND VGND VPWR VPWR _0442_ sky130_fd_sc_hd__o21ba_1
X_2352_ net251 net114 net102 net175 VGND VGND VPWR VPWR _0048_ sky130_fd_sc_hd__a22o_1
X_1234_ _0360_ _0361_ net105 VGND VGND VPWR VPWR _0373_ sky130_fd_sc_hd__o21a_1
XTAP_TAPCELL_ROW_22_228 VGND VPWR sky130_fd_sc_hd__tapvpwrvgnd_1
X_1998_ _1133_ _1136_ VGND VGND VPWR VPWR _1137_ sky130_fd_sc_hd__xnor2_1
XTAP_TAPCELL_ROW_30_272 VGND VPWR sky130_fd_sc_hd__tapvpwrvgnd_1
XFILLER_47_119 VGND VGND VPWR VPWR sky130_fd_sc_hd__fill_1
XPHY_EDGE_ROW_41_Left_91 VGND VGND VPWR VPWR sky130_fd_sc_hd__decap_3
XFILLER_18_66 VPWR VGND VPWR VGND sky130_ef_sc_hd__decap_12
XFILLER_7_237 VPWR VGND VPWR VGND sky130_ef_sc_hd__decap_12
XFILLER_11_211 VGND VGND VPWR VPWR sky130_fd_sc_hd__decap_3
XFILLER_11_266 VPWR VGND VPWR VGND sky130_ef_sc_hd__decap_12
XFILLER_46_141 VGND VGND VPWR VPWR sky130_fd_sc_hd__fill_2
X_1852_ _0989_ _0990_ net164 net117 VGND VGND VPWR VPWR _0991_ sky130_fd_sc_hd__and4bb_1
X_1921_ _1058_ _1045_ VGND VGND VPWR VPWR _1060_ sky130_fd_sc_hd__xnor2_2
X_1783_ _0802_ _0808_ _0807_ VGND VGND VPWR VPWR _0922_ sky130_fd_sc_hd__a21o_1
X_2404_ clknet_2_1__leaf_clk _0044_ net136 VGND VGND VPWR VPWR net31 sky130_fd_sc_hd__dfrtp_1
X_2266_ _0085_ _0266_ VGND VGND VPWR VPWR _0267_ sky130_fd_sc_hd__xor2_1
XFILLER_29_108 VGND VGND VPWR VPWR sky130_fd_sc_hd__fill_1
X_2335_ net88 _0318_ net68 net114 VGND VGND VPWR VPWR _0031_ sky130_fd_sc_hd__a2bb2o_1
XFILLER_40_306 VGND VGND VPWR VPWR sky130_fd_sc_hd__fill_2
X_1217_ net95 _0355_ VGND VGND VPWR VPWR _0356_ sky130_fd_sc_hd__and2_1
X_2197_ _0203_ _0207_ VGND VGND VPWR VPWR _0212_ sky130_fd_sc_hd__nand2_1
XFILLER_29_21 VPWR VGND VPWR VGND sky130_ef_sc_hd__decap_12
Xhold65 net42 VGND VGND VPWR VPWR net256 sky130_fd_sc_hd__dlygate4sd3_1
Xhold87 net55 VGND VGND VPWR VPWR net278 sky130_fd_sc_hd__dlygate4sd3_1
Xhold76 net38 VGND VGND VPWR VPWR net267 sky130_fd_sc_hd__dlygate4sd3_1
XFILLER_45_64 VGND VGND VPWR VPWR sky130_fd_sc_hd__decap_6
XFILLER_43_111 VGND VGND VPWR VPWR sky130_fd_sc_hd__fill_1
XTAP_TAPCELL_ROW_41_334 VGND VPWR sky130_fd_sc_hd__tapvpwrvgnd_1
X_2120_ _0079_ _0133_ VGND VGND VPWR VPWR _0135_ sky130_fd_sc_hd__and2_1
X_2051_ _0061_ _0064_ _0065_ VGND VGND VPWR VPWR _0066_ sky130_fd_sc_hd__nand3_1
XFILLER_34_100 VGND VGND VPWR VPWR sky130_fd_sc_hd__decap_4
X_1835_ _0905_ _0972_ _0973_ VGND VGND VPWR VPWR _0974_ sky130_fd_sc_hd__and3_1
X_1904_ _1039_ _1042_ _1025_ _1010_ VGND VGND VPWR VPWR _1043_ sky130_fd_sc_hd__o211a_1
X_1697_ _0834_ _0835_ VGND VGND VPWR VPWR _0836_ sky130_fd_sc_hd__nor2_1
X_1766_ net147 net143 net191 net119 VGND VGND VPWR VPWR _0905_ sky130_fd_sc_hd__nand4_1
X_2249_ _0947_ _1085_ VGND VGND VPWR VPWR _0254_ sky130_fd_sc_hd__or2_1
X_2318_ _0189_ _0303_ _0188_ VGND VGND VPWR VPWR _0306_ sky130_fd_sc_hd__a21o_1
XFILLER_25_188 VPWR VGND VPWR VGND sky130_ef_sc_hd__decap_12
XFILLER_25_122 VGND VGND VPWR VPWR sky130_fd_sc_hd__decap_8
XFILLER_25_100 VGND VGND VPWR VPWR sky130_fd_sc_hd__fill_2
XFILLER_15_23 VGND VGND VPWR VPWR sky130_fd_sc_hd__decap_6
XFILLER_15_45 VGND VGND VPWR VPWR sky130_fd_sc_hd__decap_8
XFILLER_15_78 VGND VGND VPWR VPWR sky130_fd_sc_hd__decap_6
XFILLER_31_99 VGND VGND VPWR VPWR sky130_fd_sc_hd__decap_3
Xoutput33 net33 VGND VGND VPWR VPWR a_out[14] sky130_fd_sc_hd__buf_2
Xoutput77 net77 VGND VGND VPWR VPWR b_out[1] sky130_fd_sc_hd__buf_2
Xoutput44 net44 VGND VGND VPWR VPWR acc_out[0] sky130_fd_sc_hd__buf_2
Xoutput66 net66 VGND VGND VPWR VPWR acc_out[2] sky130_fd_sc_hd__buf_2
Xoutput55 net55 VGND VGND VPWR VPWR acc_out[1] sky130_fd_sc_hd__buf_2
XFILLER_0_221 VGND VGND VPWR VPWR sky130_fd_sc_hd__decap_3
XFILLER_0_265 VPWR VGND VPWR VGND sky130_ef_sc_hd__decap_12
XFILLER_31_169 VGND VGND VPWR VPWR sky130_fd_sc_hd__decap_4
XFILLER_16_188 VGND VGND VPWR VPWR sky130_fd_sc_hd__decap_4
X_1551_ _0687_ _0689_ VGND VGND VPWR VPWR _0690_ sky130_fd_sc_hd__nor2_1
X_1482_ _0618_ _0620_ VGND VGND VPWR VPWR _0621_ sky130_fd_sc_hd__nor2_1
X_1620_ _0723_ _0728_ VGND VGND VPWR VPWR _0759_ sky130_fd_sc_hd__xnor2_1
X_2103_ _0115_ _0116_ _0117_ VGND VGND VPWR VPWR _0118_ sky130_fd_sc_hd__nand3_1
X_2034_ net146 net177 net159 net22 VGND VGND VPWR VPWR _1173_ sky130_fd_sc_hd__a22oi_1
X_1818_ _0955_ _0956_ net164 net188 VGND VGND VPWR VPWR _0957_ sky130_fd_sc_hd__and4bb_1
XFILLER_10_309 VGND VGND VPWR VPWR sky130_fd_sc_hd__fill_1
X_1749_ _0884_ _0887_ VGND VGND VPWR VPWR _0888_ sky130_fd_sc_hd__xnor2_1
XFILLER_45_239 VGND VGND VPWR VPWR sky130_fd_sc_hd__fill_1
XFILLER_45_217 VGND VGND VPWR VPWR sky130_fd_sc_hd__fill_1
XFILLER_26_44 VGND VGND VPWR VPWR sky130_fd_sc_hd__fill_1
XFILLER_9_129 VGND VGND VPWR VPWR sky130_fd_sc_hd__fill_2
XFILLER_13_103 VGND VGND VPWR VPWR sky130_fd_sc_hd__fill_1
XFILLER_13_136 VGND VGND VPWR VPWR sky130_fd_sc_hd__fill_1
XFILLER_13_169 VPWR VGND VPWR VGND sky130_ef_sc_hd__decap_12
XFILLER_3_15 VPWR VGND VPWR VGND sky130_ef_sc_hd__decap_12
XTAP_TAPCELL_ROW_8_151 VGND VPWR sky130_fd_sc_hd__tapvpwrvgnd_1
XFILLER_44_294 VPWR VGND VPWR VGND sky130_ef_sc_hd__decap_12
XTAP_TAPCELL_ROW_14_186 VGND VPWR sky130_fd_sc_hd__tapvpwrvgnd_1
X_1534_ _0670_ _0672_ _0635_ _0669_ VGND VGND VPWR VPWR _0673_ sky130_fd_sc_hd__a211o_1
X_1465_ _0603_ _0592_ VGND VGND VPWR VPWR _0604_ sky130_fd_sc_hd__and2b_1
Xfanout108 net109 VGND VGND VPWR VPWR net108 sky130_fd_sc_hd__clkbuf_2
X_1603_ _0739_ _0740_ _0741_ VGND VGND VPWR VPWR _0742_ sky130_fd_sc_hd__nand3_1
Xfanout119 net8 VGND VGND VPWR VPWR net119 sky130_fd_sc_hd__buf_2
X_2017_ _1153_ _1154_ _1147_ VGND VGND VPWR VPWR _1156_ sky130_fd_sc_hd__a21o_1
X_1396_ _0533_ _0534_ VGND VGND VPWR VPWR _0535_ sky130_fd_sc_hd__nor2_1
XFILLER_35_294 VGND VGND VPWR VPWR sky130_fd_sc_hd__decap_4
XFILLER_35_261 VGND VGND VPWR VPWR sky130_fd_sc_hd__decap_6
XFILLER_37_43 VGND VGND VPWR VPWR sky130_fd_sc_hd__decap_3
XFILLER_33_209 VPWR VGND VPWR VGND sky130_ef_sc_hd__decap_12
XFILLER_26_261 VGND VGND VPWR VPWR sky130_fd_sc_hd__fill_2
XTAP_TAPCELL_ROW_11_167 VGND VPWR sky130_fd_sc_hd__tapvpwrvgnd_1
X_1181_ net117 VGND VGND VPWR VPWR _0320_ sky130_fd_sc_hd__inv_2
X_1250_ _0386_ _0388_ VGND VGND VPWR VPWR _0389_ sky130_fd_sc_hd__nor2_1
XTAP_TAPCELL_ROW_19_212 VGND VPWR sky130_fd_sc_hd__tapvpwrvgnd_1
XFILLER_32_275 VPWR VGND VPWR VGND sky130_ef_sc_hd__decap_12
XFILLER_32_253 VGND VGND VPWR VPWR sky130_fd_sc_hd__decap_3
X_1517_ _0649_ _0654_ VGND VGND VPWR VPWR _0656_ sky130_fd_sc_hd__xnor2_1
X_1448_ _0584_ _0586_ _0530_ _0558_ VGND VGND VPWR VPWR _0587_ sky130_fd_sc_hd__o211ai_2
X_1379_ _0332_ _0516_ VGND VGND VPWR VPWR _0518_ sky130_fd_sc_hd__and2_1
XFILLER_48_53 VPWR VGND VPWR VGND sky130_ef_sc_hd__decap_12
XFILLER_0_49 VGND VGND VPWR VPWR sky130_fd_sc_hd__decap_3
XFILLER_14_297 VGND VGND VPWR VPWR sky130_fd_sc_hd__fill_2
Xfanout90 _0227_ VGND VGND VPWR VPWR net90 sky130_fd_sc_hd__buf_6
X_2282_ _0123_ _0278_ VGND VGND VPWR VPWR _0279_ sky130_fd_sc_hd__xor2_1
XFILLER_29_3 VGND VGND VPWR VPWR sky130_fd_sc_hd__fill_1
X_1233_ net95 _0365_ VGND VGND VPWR VPWR _0372_ sky130_fd_sc_hd__xor2_1
X_1302_ _0439_ _0440_ VGND VGND VPWR VPWR _0441_ sky130_fd_sc_hd__nor2_1
X_2351_ net246 net114 net102 net123 VGND VGND VPWR VPWR _0047_ sky130_fd_sc_hd__a22o_1
XFILLER_49_194 VGND VGND VPWR VPWR sky130_fd_sc_hd__fill_2
X_1997_ _1134_ _1135_ VGND VGND VPWR VPWR _1136_ sky130_fd_sc_hd__nor2_1
XTAP_TAPCELL_ROW_22_229 VGND VPWR sky130_fd_sc_hd__tapvpwrvgnd_1
XTAP_TAPCELL_ROW_30_273 VGND VPWR sky130_fd_sc_hd__tapvpwrvgnd_1
XFILLER_28_301 VGND VGND VPWR VPWR sky130_fd_sc_hd__decap_3
XFILLER_18_78 VGND VGND VPWR VPWR sky130_fd_sc_hd__decap_6
XFILLER_7_249 VGND VGND VPWR VPWR sky130_fd_sc_hd__decap_8
XFILLER_11_278 VGND VGND VPWR VPWR sky130_fd_sc_hd__fill_2
XFILLER_46_197 VGND VGND VPWR VPWR sky130_fd_sc_hd__decap_8
XFILLER_46_164 VGND VGND VPWR VPWR sky130_fd_sc_hd__decap_6
XFILLER_46_131 VGND VGND VPWR VPWR sky130_fd_sc_hd__fill_2
X_1851_ net168 net188 net69 VGND VGND VPWR VPWR _0990_ sky130_fd_sc_hd__a21oi_1
X_1920_ _1045_ _1058_ VGND VGND VPWR VPWR _1059_ sky130_fd_sc_hd__nand2_1
X_2403_ clknet_2_3__leaf_clk _0043_ net139 VGND VGND VPWR VPWR net30 sky130_fd_sc_hd__dfrtp_1
X_1782_ _0918_ _0919_ VGND VGND VPWR VPWR _0921_ sky130_fd_sc_hd__xnor2_1
X_2265_ _1089_ _1129_ _0088_ VGND VGND VPWR VPWR _0266_ sky130_fd_sc_hd__a21bo_1
X_1216_ _0349_ _0353_ VGND VGND VPWR VPWR _0355_ sky130_fd_sc_hd__xor2_1
X_2196_ _0196_ _0192_ _0205_ _0210_ VGND VGND VPWR VPWR _0211_ sky130_fd_sc_hd__a211o_1
X_2334_ _0216_ net84 net102 VGND VGND VPWR VPWR _0318_ sky130_fd_sc_hd__a21bo_1
XFILLER_29_33 VPWR VGND VPWR VGND sky130_ef_sc_hd__decap_12
Xhold66 net29 VGND VGND VPWR VPWR net257 sky130_fd_sc_hd__dlygate4sd3_1
XFILLER_45_54 VGND VGND VPWR VPWR sky130_fd_sc_hd__fill_2
Xhold88 net64 VGND VGND VPWR VPWR net279 sky130_fd_sc_hd__dlygate4sd3_1
Xhold77 net83 VGND VGND VPWR VPWR net268 sky130_fd_sc_hd__dlygate4sd3_1
Xhold55 net34 VGND VGND VPWR VPWR net246 sky130_fd_sc_hd__dlygate4sd3_1
XFILLER_43_189 VGND VGND VPWR VPWR sky130_fd_sc_hd__fill_2
XFILLER_43_167 VGND VGND VPWR VPWR sky130_fd_sc_hd__fill_1
XTAP_TAPCELL_ROW_41_335 VGND VPWR sky130_fd_sc_hd__tapvpwrvgnd_1
XFILLER_6_15 VGND VGND VPWR VPWR sky130_fd_sc_hd__decap_6
X_2050_ _0672_ _0062_ _0063_ VGND VGND VPWR VPWR _0065_ sky130_fd_sc_hd__a21o_1
XFILLER_19_120 VGND VGND VPWR VPWR sky130_fd_sc_hd__decap_8
XFILLER_22_307 VGND VGND VPWR VPWR sky130_fd_sc_hd__fill_1
X_1834_ net143 net191 net119 net147 VGND VGND VPWR VPWR _0973_ sky130_fd_sc_hd__a22o_1
X_1903_ _1039_ _1040_ _1034_ VGND VGND VPWR VPWR _1042_ sky130_fd_sc_hd__nor3b_1
X_1765_ net147 net143 net191 net119 VGND VGND VPWR VPWR _0904_ sky130_fd_sc_hd__and4_1
X_1696_ net145 net183 net181 net150 VGND VGND VPWR VPWR _0835_ sky130_fd_sc_hd__a22oi_1
X_2317_ net283 net114 _0305_ net102 VGND VGND VPWR VPWR _0026_ sky130_fd_sc_hd__a22o_1
X_2179_ _0190_ _0193_ VGND VGND VPWR VPWR _0194_ sky130_fd_sc_hd__nand2b_1
X_2248_ net75 net111 net99 _0253_ VGND VGND VPWR VPWR _0009_ sky130_fd_sc_hd__a22o_1
XFILLER_25_167 VGND VGND VPWR VPWR sky130_fd_sc_hd__fill_1
XFILLER_15_57 VGND VGND VPWR VPWR sky130_fd_sc_hd__decap_8
Xoutput34 net34 VGND VGND VPWR VPWR a_out[15] sky130_fd_sc_hd__buf_2
Xoutput56 net56 VGND VGND VPWR VPWR acc_out[20] sky130_fd_sc_hd__buf_2
Xoutput45 net45 VGND VGND VPWR VPWR acc_out[10] sky130_fd_sc_hd__buf_2
Xoutput78 net78 VGND VGND VPWR VPWR b_out[2] sky130_fd_sc_hd__buf_2
Xoutput67 net67 VGND VGND VPWR VPWR acc_out[30] sky130_fd_sc_hd__buf_2
XFILLER_0_277 VGND VGND VPWR VPWR sky130_fd_sc_hd__decap_3
X_1550_ net144 net158 net133 net149 VGND VGND VPWR VPWR _0689_ sky130_fd_sc_hd__a22oi_1
X_1481_ _0583_ _0591_ _0604_ _0617_ VGND VGND VPWR VPWR _0620_ sky130_fd_sc_hd__a211oi_1
XFILLER_47_281 VPWR VGND VPWR VGND sky130_ef_sc_hd__decap_12
X_2033_ net149 net144 net177 net159 VGND VGND VPWR VPWR _1172_ sky130_fd_sc_hd__and4_1
X_2102_ _0105_ _0114_ _0069_ _0072_ VGND VGND VPWR VPWR _0117_ sky130_fd_sc_hd__o211ai_1
X_1817_ net168 net186 net70 VGND VGND VPWR VPWR _0956_ sky130_fd_sc_hd__a21oi_1
X_1748_ _0885_ _0886_ VGND VGND VPWR VPWR _0887_ sky130_fd_sc_hd__and2b_1
X_1679_ net119 net141 VGND VGND VPWR VPWR _0818_ sky130_fd_sc_hd__nand2b_1
XFILLER_42_44 VGND VGND VPWR VPWR sky130_fd_sc_hd__decap_8
XFILLER_21_181 VGND VGND VPWR VPWR sky130_fd_sc_hd__decap_4
XFILLER_3_27 VPWR VGND VPWR VGND sky130_ef_sc_hd__decap_12
XTAP_TAPCELL_ROW_8_152 VGND VPWR sky130_fd_sc_hd__tapvpwrvgnd_1
XFILLER_29_281 VGND VGND VPWR VPWR sky130_fd_sc_hd__decap_8
XFILLER_29_270 VGND VGND VPWR VPWR sky130_fd_sc_hd__decap_8
XFILLER_44_251 VGND VGND VPWR VPWR sky130_fd_sc_hd__fill_1
X_1602_ _0737_ _0738_ _0730_ _0732_ VGND VGND VPWR VPWR _0741_ sky130_fd_sc_hd__a211o_1
XFILLER_8_141 VGND VGND VPWR VPWR sky130_fd_sc_hd__decap_8
XFILLER_8_163 VGND VGND VPWR VPWR sky130_fd_sc_hd__fill_2
XTAP_TAPCELL_ROW_14_187 VGND VPWR sky130_fd_sc_hd__tapvpwrvgnd_1
X_1533_ net167 net128 _0670_ _0671_ VGND VGND VPWR VPWR _0672_ sky130_fd_sc_hd__nand4_2
X_1464_ _0598_ _0602_ VGND VGND VPWR VPWR _0603_ sky130_fd_sc_hd__and2_1
Xfanout109 _0343_ VGND VGND VPWR VPWR net109 sky130_fd_sc_hd__clkbuf_2
X_1395_ net172 net122 net60 VGND VGND VPWR VPWR _0534_ sky130_fd_sc_hd__a21oi_1
X_2016_ _1147_ _1153_ _1154_ VGND VGND VPWR VPWR _1155_ sky130_fd_sc_hd__nand3_1
XFILLER_2_317 VGND VGND VPWR VPWR sky130_fd_sc_hd__decap_3
XTAP_TAPCELL_ROW_5_133 VGND VPWR sky130_fd_sc_hd__tapvpwrvgnd_1
XTAP_TAPCELL_ROW_11_168 VGND VPWR sky130_fd_sc_hd__tapvpwrvgnd_1
XFILLER_5_199 VGND VGND VPWR VPWR sky130_fd_sc_hd__fill_1
XFILLER_5_166 VGND VGND VPWR VPWR sky130_fd_sc_hd__fill_2
XTAP_TAPCELL_ROW_19_213 VGND VPWR sky130_fd_sc_hd__tapvpwrvgnd_1
X_1180_ net167 VGND VGND VPWR VPWR _0319_ sky130_fd_sc_hd__inv_2
X_1516_ _0654_ _0649_ VGND VGND VPWR VPWR _0655_ sky130_fd_sc_hd__nand2b_1
X_1447_ _0572_ _0579_ _0584_ _0585_ VGND VGND VPWR VPWR _0586_ sky130_fd_sc_hd__a211oi_2
X_1378_ _0332_ _0516_ VGND VGND VPWR VPWR _0517_ sky130_fd_sc_hd__nor2_1
XFILLER_23_232 VGND VGND VPWR VPWR sky130_fd_sc_hd__decap_8
XFILLER_23_254 VGND VGND VPWR VPWR sky130_fd_sc_hd__fill_1
XFILLER_23_57 VGND VGND VPWR VPWR sky130_fd_sc_hd__fill_1
XFILLER_2_147 VGND VGND VPWR VPWR sky130_fd_sc_hd__decap_3
XFILLER_48_65 VPWR VGND VPWR VGND sky130_ef_sc_hd__decap_12
Xfanout91 _0227_ VGND VGND VPWR VPWR net91 sky130_fd_sc_hd__clkbuf_2
XFILLER_14_276 VGND VGND VPWR VPWR sky130_fd_sc_hd__decap_8
X_2281_ _0132_ _0272_ _0139_ VGND VGND VPWR VPWR _0278_ sky130_fd_sc_hd__o21a_1
X_2350_ net281 net112 net100 net127 VGND VGND VPWR VPWR _0046_ sky130_fd_sc_hd__a22o_1
X_1301_ net172 net122 net61 VGND VGND VPWR VPWR _0440_ sky130_fd_sc_hd__a21oi_1
X_1232_ _0340_ _0369_ VGND VGND VPWR VPWR _0371_ sky130_fd_sc_hd__xnor2_1
X_1996_ net145 net179 net177 net150 VGND VGND VPWR VPWR _1135_ sky130_fd_sc_hd__a22oi_1
XTAP_TAPCELL_ROW_30_274 VGND VPWR sky130_fd_sc_hd__tapvpwrvgnd_1
XFILLER_20_235 VGND VGND VPWR VPWR sky130_fd_sc_hd__decap_4
XFILLER_43_305 VPWR VGND VPWR VGND sky130_ef_sc_hd__decap_12
XFILLER_11_235 VGND VGND VPWR VPWR sky130_fd_sc_hd__fill_1
Xclkload0 clknet_2_0__leaf_clk VGND VGND VPWR VPWR clkload0/X sky130_fd_sc_hd__clkbuf_4
XFILLER_46_176 VPWR VGND VPWR VGND sky130_ef_sc_hd__decap_12
XPHY_EDGE_ROW_28_Left_78 VGND VGND VPWR VPWR sky130_fd_sc_hd__decap_3
X_1850_ net168 net188 net69 VGND VGND VPWR VPWR _0989_ sky130_fd_sc_hd__and3_1
X_1781_ _0919_ _0918_ VGND VGND VPWR VPWR _0920_ sky130_fd_sc_hd__and2b_1
X_2402_ clknet_2_1__leaf_clk _0042_ net136 VGND VGND VPWR VPWR net29 sky130_fd_sc_hd__dfrtp_1
X_2333_ net67 net113 _0317_ net101 VGND VGND VPWR VPWR _0030_ sky130_fd_sc_hd__a22o_1
XFILLER_37_110 VGND VGND VPWR VPWR sky130_fd_sc_hd__fill_2
X_2264_ net48 net112 net100 _0265_ VGND VGND VPWR VPWR _0013_ sky130_fd_sc_hd__a22o_1
X_1215_ _0349_ _0353_ VGND VGND VPWR VPWR _0354_ sky130_fd_sc_hd__and2_1
X_2195_ _0208_ _0209_ VGND VGND VPWR VPWR _0210_ sky130_fd_sc_hd__nand2_1
XTAP_TAPCELL_ROW_35_300 VGND VPWR sky130_fd_sc_hd__tapvpwrvgnd_1
X_1979_ _1113_ _1114_ _1115_ VGND VGND VPWR VPWR _1118_ sky130_fd_sc_hd__a21o_1
XFILLER_20_14 VGND VGND VPWR VPWR sky130_fd_sc_hd__fill_1
XFILLER_20_58 VGND VGND VPWR VPWR sky130_fd_sc_hd__fill_2
XFILLER_29_45 VGND VGND VPWR VPWR sky130_fd_sc_hd__decap_6
Xhold56 net37 VGND VGND VPWR VPWR net247 sky130_fd_sc_hd__dlygate4sd3_1
XFILLER_45_99 VPWR VGND VPWR VGND sky130_ef_sc_hd__decap_12
XFILLER_45_88 VGND VGND VPWR VPWR sky130_fd_sc_hd__decap_4
XFILLER_43_113 VGND VGND VPWR VPWR sky130_fd_sc_hd__decap_3
Xhold89 net52 VGND VGND VPWR VPWR net280 sky130_fd_sc_hd__dlygate4sd3_1
Xhold78 net56 VGND VGND VPWR VPWR net269 sky130_fd_sc_hd__dlygate4sd3_1
XFILLER_28_187 VGND VGND VPWR VPWR sky130_fd_sc_hd__decap_8
Xhold67 net82 VGND VGND VPWR VPWR net258 sky130_fd_sc_hd__dlygate4sd3_1
XFILLER_3_253 VPWR VGND VPWR VGND sky130_ef_sc_hd__decap_12
XFILLER_19_110 VGND VGND VPWR VPWR sky130_fd_sc_hd__fill_2
X_1902_ _1039_ _1040_ VGND VGND VPWR VPWR _1041_ sky130_fd_sc_hd__nor2_1
X_1833_ net151 net119 _0964_ _0963_ VGND VGND VPWR VPWR _0972_ sky130_fd_sc_hd__a31o_1
X_1764_ net143 net119 VGND VGND VPWR VPWR _0903_ sky130_fd_sc_hd__nand2_1
X_1695_ net150 net145 net183 net181 VGND VGND VPWR VPWR _0834_ sky130_fd_sc_hd__and4_1
X_2316_ net85 _0304_ net89 VGND VGND VPWR VPWR _0305_ sky130_fd_sc_hd__a21o_1
XFILLER_25_113 VGND VGND VPWR VPWR sky130_fd_sc_hd__fill_2
X_2178_ _0553_ _0555_ _0163_ VGND VGND VPWR VPWR _0193_ sky130_fd_sc_hd__a21oi_1
X_2247_ net86 _0252_ net90 VGND VGND VPWR VPWR _0253_ sky130_fd_sc_hd__a21o_1
XFILLER_40_116 VGND VGND VPWR VPWR sky130_fd_sc_hd__fill_1
Xoutput46 net46 VGND VGND VPWR VPWR acc_out[11] sky130_fd_sc_hd__buf_2
Xoutput57 net57 VGND VGND VPWR VPWR acc_out[21] sky130_fd_sc_hd__buf_2
Xoutput35 net35 VGND VGND VPWR VPWR a_out[1] sky130_fd_sc_hd__buf_2
Xoutput68 net68 VGND VGND VPWR VPWR acc_out[31] sky130_fd_sc_hd__buf_2
Xoutput79 net79 VGND VGND VPWR VPWR b_out[3] sky130_fd_sc_hd__buf_2
XPHY_EDGE_ROW_19_Right_19 VGND VGND VPWR VPWR sky130_fd_sc_hd__decap_3
X_1480_ _0605_ _0606_ _0613_ VGND VGND VPWR VPWR _0619_ sky130_fd_sc_hd__o21ai_1
XPHY_EDGE_ROW_28_Right_28 VGND VGND VPWR VPWR sky130_fd_sc_hd__decap_3
XFILLER_47_293 VPWR VGND VPWR VGND sky130_ef_sc_hd__decap_12
X_2032_ net179 net142 VGND VGND VPWR VPWR _1171_ sky130_fd_sc_hd__nand2b_1
X_2101_ _1177_ _1179_ _1176_ VGND VGND VPWR VPWR _0116_ sky130_fd_sc_hd__a21o_1
XPHY_EDGE_ROW_37_Right_37 VGND VGND VPWR VPWR sky130_fd_sc_hd__decap_3
XPHY_EDGE_ROW_46_Right_46 VGND VGND VPWR VPWR sky130_fd_sc_hd__decap_3
XFILLER_30_193 VGND VGND VPWR VPWR sky130_fd_sc_hd__decap_3
X_1816_ net168 net186 net70 VGND VGND VPWR VPWR _0955_ sky130_fd_sc_hd__and3_4
X_1747_ net154 net188 net186 net160 VGND VGND VPWR VPWR _0886_ sky130_fd_sc_hd__a22o_1
X_1678_ net147 net143 net117 net189 VGND VGND VPWR VPWR _0817_ sky130_fd_sc_hd__and4_1
XPHY_EDGE_ROW_15_Left_65 VGND VGND VPWR VPWR sky130_fd_sc_hd__decap_3
XFILLER_26_13 VGND VGND VPWR VPWR sky130_fd_sc_hd__decap_3
XFILLER_42_67 VGND VGND VPWR VPWR sky130_fd_sc_hd__fill_1
XFILLER_5_304 VPWR VGND VPWR VGND sky130_ef_sc_hd__decap_12
XTAP_TAPCELL_ROW_8_153 VGND VPWR sky130_fd_sc_hd__tapvpwrvgnd_1
X_1532_ net171 net125 net50 VGND VGND VPWR VPWR _0671_ sky130_fd_sc_hd__a21o_1
X_1601_ _0714_ _0715_ VGND VGND VPWR VPWR _0740_ sky130_fd_sc_hd__xnor2_1
XFILLER_8_175 VGND VGND VPWR VPWR sky130_fd_sc_hd__decap_6
X_1463_ _0598_ _0600_ _0601_ VGND VGND VPWR VPWR _0602_ sky130_fd_sc_hd__nand3_1
X_1394_ net172 net122 net60 VGND VGND VPWR VPWR _0533_ sky130_fd_sc_hd__and3_1
X_2015_ _1151_ _1152_ _1106_ _1108_ VGND VGND VPWR VPWR _1154_ sky130_fd_sc_hd__a211o_1
XFILLER_2_307 VGND VGND VPWR VPWR sky130_fd_sc_hd__fill_1
XTAP_TAPCELL_ROW_5_134 VGND VPWR sky130_fd_sc_hd__tapvpwrvgnd_1
XFILLER_41_266 VGND VGND VPWR VPWR sky130_fd_sc_hd__fill_1
XFILLER_41_244 VGND VGND VPWR VPWR sky130_fd_sc_hd__fill_2
XTAP_TAPCELL_ROW_11_169 VGND VPWR sky130_fd_sc_hd__tapvpwrvgnd_1
XFILLER_17_241 VGND VGND VPWR VPWR sky130_fd_sc_hd__decap_8
XTAP_TAPCELL_ROW_19_214 VGND VPWR sky130_fd_sc_hd__tapvpwrvgnd_1
XFILLER_32_299 VGND VGND VPWR VPWR sky130_fd_sc_hd__fill_2
X_1515_ _0651_ _0652_ _0650_ VGND VGND VPWR VPWR _0654_ sky130_fd_sc_hd__o21ba_1
X_1446_ _0559_ _0570_ _0583_ VGND VGND VPWR VPWR _0585_ sky130_fd_sc_hd__and3_1
X_1377_ _0335_ _0459_ VGND VGND VPWR VPWR _0516_ sky130_fd_sc_hd__xnor2_1
XFILLER_23_36 VGND VGND VPWR VPWR sky130_fd_sc_hd__decap_6
XFILLER_23_222 VGND VGND VPWR VPWR sky130_fd_sc_hd__fill_2
XFILLER_23_266 VPWR VGND VPWR VGND sky130_ef_sc_hd__decap_12
XFILLER_48_77 VGND VGND VPWR VPWR sky130_fd_sc_hd__decap_6
XFILLER_0_29 VGND VGND VPWR VPWR sky130_fd_sc_hd__decap_8
Xfanout92 _0387_ VGND VGND VPWR VPWR net92 sky130_fd_sc_hd__clkbuf_4
XFILLER_9_38 VGND VGND VPWR VPWR sky130_fd_sc_hd__decap_6
XFILLER_49_141 VGND VGND VPWR VPWR sky130_fd_sc_hd__fill_2
X_2280_ net280 net115 net103 _0277_ VGND VGND VPWR VPWR _0017_ sky130_fd_sc_hd__a22o_1
X_1300_ net172 net122 net61 VGND VGND VPWR VPWR _0439_ sky130_fd_sc_hd__and3_1
X_1231_ net94 _0369_ VGND VGND VPWR VPWR _0370_ sky130_fd_sc_hd__nor2_1
XTAP_TAPCELL_ROW_47_364 VGND VPWR sky130_fd_sc_hd__tapvpwrvgnd_1
X_1995_ net150 net145 net179 net177 VGND VGND VPWR VPWR _1134_ sky130_fd_sc_hd__and4_1
XTAP_TAPCELL_ROW_30_275 VGND VPWR sky130_fd_sc_hd__tapvpwrvgnd_1
XFILLER_20_269 VGND VGND VPWR VPWR sky130_fd_sc_hd__fill_1
X_1429_ _0566_ _0567_ VGND VGND VPWR VPWR _0568_ sky130_fd_sc_hd__nor2_1
XFILLER_43_317 VGND VGND VPWR VPWR sky130_fd_sc_hd__decap_3
XFILLER_18_36 VGND VGND VPWR VPWR sky130_fd_sc_hd__decap_3
XFILLER_34_35 VGND VGND VPWR VPWR sky130_fd_sc_hd__decap_4
Xclkload1 clknet_2_3__leaf_clk VGND VGND VPWR VPWR clkload1/Y sky130_fd_sc_hd__bufinv_16
XFILLER_11_203 VGND VGND VPWR VPWR sky130_fd_sc_hd__decap_8
XFILLER_1_3 VPWR VGND VPWR VGND sky130_ef_sc_hd__decap_12
XPHY_EDGE_ROW_3_Left_53 VGND VGND VPWR VPWR sky130_fd_sc_hd__decap_3
XFILLER_46_188 VGND VGND VPWR VPWR sky130_fd_sc_hd__decap_8
X_1780_ _0903_ _0908_ _0907_ VGND VGND VPWR VPWR _0919_ sky130_fd_sc_hd__o21ba_1
X_2401_ clknet_2_1__leaf_clk _0041_ net136 VGND VGND VPWR VPWR net43 sky130_fd_sc_hd__dfrtp_1
XFILLER_34_3 VGND VGND VPWR VPWR sky130_fd_sc_hd__fill_2
X_2332_ _0213_ net85 _0316_ net89 VGND VGND VPWR VPWR _0317_ sky130_fd_sc_hd__a31o_1
XFILLER_37_199 VGND VGND VPWR VPWR sky130_fd_sc_hd__fill_1
XFILLER_37_155 VGND VGND VPWR VPWR sky130_fd_sc_hd__fill_1
XTAP_TAPCELL_ROW_35_301 VGND VPWR sky130_fd_sc_hd__tapvpwrvgnd_1
X_2263_ net86 _0263_ _0264_ net90 VGND VGND VPWR VPWR _0265_ sky130_fd_sc_hd__a31o_1
XFILLER_1_61 VGND VGND VPWR VPWR sky130_fd_sc_hd__fill_1
X_1214_ _0350_ _0352_ VGND VGND VPWR VPWR _0353_ sky130_fd_sc_hd__or2_1
X_2194_ _0200_ _0207_ VGND VGND VPWR VPWR _0209_ sky130_fd_sc_hd__or2_1
XFILLER_40_309 VGND VGND VPWR VPWR sky130_fd_sc_hd__decap_6
X_1978_ _1116_ VGND VGND VPWR VPWR _1117_ sky130_fd_sc_hd__inv_2
XFILLER_20_26 VGND VGND VPWR VPWR sky130_fd_sc_hd__fill_2
Xhold57 net30 VGND VGND VPWR VPWR net248 sky130_fd_sc_hd__dlygate4sd3_1
XPHY_EDGE_ROW_45_Left_95 VGND VGND VPWR VPWR sky130_fd_sc_hd__decap_3
Xhold79 net57 VGND VGND VPWR VPWR net270 sky130_fd_sc_hd__dlygate4sd3_1
XFILLER_29_57 VGND VGND VPWR VPWR sky130_fd_sc_hd__fill_2
Xhold68 net77 VGND VGND VPWR VPWR net259 sky130_fd_sc_hd__dlygate4sd3_1
XFILLER_43_169 VGND VGND VPWR VPWR sky130_fd_sc_hd__decap_4
XFILLER_16_306 VGND VGND VPWR VPWR sky130_fd_sc_hd__fill_2
XFILLER_6_39 VGND VGND VPWR VPWR sky130_fd_sc_hd__decap_6
XFILLER_3_265 VPWR VGND VPWR VGND sky130_ef_sc_hd__decap_12
XFILLER_3_221 VGND VGND VPWR VPWR sky130_fd_sc_hd__decap_3
XFILLER_42_191 VGND VGND VPWR VPWR sky130_fd_sc_hd__decap_4
X_1901_ _1001_ _1026_ _1038_ VGND VGND VPWR VPWR _1040_ sky130_fd_sc_hd__a21oi_1
X_1832_ _0889_ _0969_ _0968_ VGND VGND VPWR VPWR _0971_ sky130_fd_sc_hd__a21o_1
XFILLER_22_309 VGND VGND VPWR VPWR sky130_fd_sc_hd__decap_3
X_1694_ net185 net142 VGND VGND VPWR VPWR _0833_ sky130_fd_sc_hd__nand2b_1
X_1763_ _0890_ _0900_ VGND VGND VPWR VPWR _0902_ sky130_fd_sc_hd__xor2_2
X_2315_ _0189_ _0303_ VGND VGND VPWR VPWR _0304_ sky130_fd_sc_hd__xor2_1
X_2246_ _1023_ _0251_ VGND VGND VPWR VPWR _0252_ sky130_fd_sc_hd__xnor2_1
X_2177_ _0143_ _0144_ _0190_ _0191_ VGND VGND VPWR VPWR _0192_ sky130_fd_sc_hd__a211o_1
XFILLER_33_191 VPWR VGND VPWR VGND sky130_ef_sc_hd__decap_12
XFILLER_31_14 VGND VGND VPWR VPWR sky130_fd_sc_hd__decap_6
Xoutput47 net47 VGND VGND VPWR VPWR acc_out[12] sky130_fd_sc_hd__buf_2
Xoutput58 net58 VGND VGND VPWR VPWR acc_out[22] sky130_fd_sc_hd__buf_2
Xoutput36 net36 VGND VGND VPWR VPWR a_out[2] sky130_fd_sc_hd__buf_2
Xoutput69 net69 VGND VGND VPWR VPWR acc_out[3] sky130_fd_sc_hd__buf_2
XFILLER_16_103 VPWR VGND VPWR VGND sky130_ef_sc_hd__decap_12
X_2100_ _0069_ _0072_ _0105_ _0114_ VGND VGND VPWR VPWR _0115_ sky130_fd_sc_hd__a211o_1
XFILLER_47_261 VPWR VGND VPWR VGND sky130_ef_sc_hd__decap_12
X_2031_ _1143_ _1146_ _1144_ VGND VGND VPWR VPWR _1170_ sky130_fd_sc_hd__o21ba_1
XFILLER_22_106 VGND VGND VPWR VPWR sky130_fd_sc_hd__decap_4
XFILLER_15_180 VGND VGND VPWR VPWR sky130_fd_sc_hd__fill_1
X_1815_ _0953_ VGND VGND VPWR VPWR _0954_ sky130_fd_sc_hd__inv_2
X_1746_ net160 net154 net188 net186 VGND VGND VPWR VPWR _0885_ sky130_fd_sc_hd__and4_1
X_1677_ _0813_ _0814_ VGND VGND VPWR VPWR _0816_ sky130_fd_sc_hd__xor2_1
XFILLER_38_250 VGND VGND VPWR VPWR sky130_fd_sc_hd__fill_2
X_2229_ _1057_ _1070_ _1046_ VGND VGND VPWR VPWR _0240_ sky130_fd_sc_hd__a21o_1
XFILLER_26_69 VGND VGND VPWR VPWR sky130_fd_sc_hd__fill_1
XFILLER_26_36 VGND VGND VPWR VPWR sky130_fd_sc_hd__decap_8
XFILLER_5_316 VGND VGND VPWR VPWR sky130_fd_sc_hd__decap_4
XFILLER_21_194 VGND VGND VPWR VPWR sky130_fd_sc_hd__decap_8
XTAP_TAPCELL_ROW_8_154 VGND VPWR sky130_fd_sc_hd__tapvpwrvgnd_1
XFILLER_29_250 VPWR VGND VPWR VGND sky130_ef_sc_hd__decap_12
XPHY_EDGE_ROW_32_Left_82 VGND VGND VPWR VPWR sky130_fd_sc_hd__decap_3
XFILLER_16_91 VGND VGND VPWR VPWR sky130_fd_sc_hd__fill_1
X_1531_ net171 net125 net50 VGND VGND VPWR VPWR _0670_ sky130_fd_sc_hd__nand3_2
X_1462_ _0565_ _0593_ _0594_ _0596_ VGND VGND VPWR VPWR _0601_ sky130_fd_sc_hd__a211o_1
X_1600_ _0730_ _0732_ _0737_ _0738_ VGND VGND VPWR VPWR _0739_ sky130_fd_sc_hd__o211ai_2
X_1393_ _0503_ _0531_ VGND VGND VPWR VPWR _0532_ sky130_fd_sc_hd__nand2b_1
X_2014_ _1106_ _1108_ _1151_ _1152_ VGND VGND VPWR VPWR _1153_ sky130_fd_sc_hd__o211ai_2
XFILLER_12_27 VGND VGND VPWR VPWR sky130_fd_sc_hd__fill_1
X_1729_ _0865_ _0866_ net208 _0795_ VGND VGND VPWR VPWR _0868_ sky130_fd_sc_hd__o211a_1
XTAP_TAPCELL_ROW_5_135 VGND VPWR sky130_fd_sc_hd__tapvpwrvgnd_1
XFILLER_37_57 VGND VGND VPWR VPWR sky130_fd_sc_hd__decap_8
XTAP_TAPCELL_ROW_28_259 VGND VPWR sky130_fd_sc_hd__tapvpwrvgnd_1
XFILLER_41_223 VGND VGND VPWR VPWR sky130_fd_sc_hd__fill_1
XFILLER_5_113 VGND VGND VPWR VPWR sky130_fd_sc_hd__fill_1
XFILLER_17_220 VGND VGND VPWR VPWR sky130_fd_sc_hd__decap_4
X_1514_ _0650_ _0652_ VGND VGND VPWR VPWR _0653_ sky130_fd_sc_hd__nor2_1
X_1445_ _0570_ _0583_ _0559_ VGND VGND VPWR VPWR _0584_ sky130_fd_sc_hd__a21oi_2
XFILLER_4_83 VGND VGND VPWR VPWR sky130_fd_sc_hd__fill_1
X_1376_ _0514_ _0505_ VGND VGND VPWR VPWR _0515_ sky130_fd_sc_hd__and2b_1
XTAP_TAPCELL_ROW_2_116 VGND VPWR sky130_fd_sc_hd__tapvpwrvgnd_1
XFILLER_23_278 VGND VGND VPWR VPWR sky130_fd_sc_hd__fill_2
XFILLER_14_201 VPWR VGND VPWR VGND sky130_ef_sc_hd__decap_12
XFILLER_14_234 VGND VGND VPWR VPWR sky130_fd_sc_hd__fill_1
XTAP_TAPCELL_ROW_24_240 VGND VPWR sky130_fd_sc_hd__tapvpwrvgnd_1
Xfanout93 _0387_ VGND VGND VPWR VPWR net93 sky130_fd_sc_hd__buf_2
X_1230_ _0367_ _0368_ VGND VGND VPWR VPWR _0369_ sky130_fd_sc_hd__or2_1
XTAP_TAPCELL_ROW_47_365 VGND VPWR sky130_fd_sc_hd__tapvpwrvgnd_1
X_1994_ net181 net142 VGND VGND VPWR VPWR _1133_ sky130_fd_sc_hd__nand2b_1
XFILLER_20_248 VGND VGND VPWR VPWR sky130_fd_sc_hd__decap_4
X_1428_ _0510_ _0561_ _0562_ _0564_ VGND VGND VPWR VPWR _0567_ sky130_fd_sc_hd__a211oi_1
XFILLER_18_26 VGND VGND VPWR VPWR sky130_fd_sc_hd__fill_2
X_1359_ _0486_ _0495_ VGND VGND VPWR VPWR _0498_ sky130_fd_sc_hd__xnor2_1
XTAP_TAPCELL_ROW_21_221 VGND VPWR sky130_fd_sc_hd__tapvpwrvgnd_1
XFILLER_34_307 VGND VGND VPWR VPWR sky130_fd_sc_hd__fill_1
XFILLER_40_90 VGND VGND VPWR VPWR sky130_fd_sc_hd__decap_8
X_2400_ clknet_2_1__leaf_clk _0040_ net136 VGND VGND VPWR VPWR net42 sky130_fd_sc_hd__dfrtp_1
X_2262_ _0870_ _1089_ _1129_ VGND VGND VPWR VPWR _0264_ sky130_fd_sc_hd__o21ai_1
X_1213_ net105 _0350_ _0351_ VGND VGND VPWR VPWR _0352_ sky130_fd_sc_hd__nor3_1
X_2331_ _0458_ _0208_ _0211_ _0212_ VGND VGND VPWR VPWR _0316_ sky130_fd_sc_hd__nand4_1
XFILLER_37_167 VGND VGND VPWR VPWR sky130_fd_sc_hd__fill_1
XTAP_TAPCELL_ROW_35_302 VGND VPWR sky130_fd_sc_hd__tapvpwrvgnd_1
XFILLER_1_51 VGND VGND VPWR VPWR sky130_fd_sc_hd__decap_4
X_2193_ _0200_ _0207_ VGND VGND VPWR VPWR _0208_ sky130_fd_sc_hd__nand2_1
X_1977_ _1113_ _1114_ _1115_ VGND VGND VPWR VPWR _1116_ sky130_fd_sc_hd__nand3_1
XFILLER_28_112 VGND VGND VPWR VPWR sky130_fd_sc_hd__fill_2
Xhold69 net28 VGND VGND VPWR VPWR net260 sky130_fd_sc_hd__dlygate4sd3_1
Xhold58 net41 VGND VGND VPWR VPWR net249 sky130_fd_sc_hd__dlygate4sd3_1
XFILLER_43_159 VGND VGND VPWR VPWR sky130_fd_sc_hd__fill_1
XFILLER_43_126 VGND VGND VPWR VPWR sky130_fd_sc_hd__decap_6
XFILLER_6_29 VGND VGND VPWR VPWR sky130_fd_sc_hd__fill_1
XFILLER_3_277 VGND VGND VPWR VPWR sky130_fd_sc_hd__decap_3
XFILLER_10_82 VGND VGND VPWR VPWR sky130_fd_sc_hd__fill_2
XFILLER_19_134 VGND VGND VPWR VPWR sky130_fd_sc_hd__fill_2
X_1900_ _1001_ _1026_ _1038_ VGND VGND VPWR VPWR _1039_ sky130_fd_sc_hd__and3_1
X_1831_ _0889_ _0968_ _0969_ VGND VGND VPWR VPWR _0970_ sky130_fd_sc_hd__nand3_1
X_1693_ _0775_ _0777_ _0774_ VGND VGND VPWR VPWR _0832_ sky130_fd_sc_hd__o21ba_1
X_1762_ _0900_ _0890_ VGND VGND VPWR VPWR _0901_ sky130_fd_sc_hd__and2b_1
X_2245_ _1021_ _1084_ VGND VGND VPWR VPWR _0251_ sky130_fd_sc_hd__and2_1
X_2314_ _0145_ _0165_ _0193_ VGND VGND VPWR VPWR _0303_ sky130_fd_sc_hd__a21o_1
X_2176_ _0556_ _0164_ VGND VGND VPWR VPWR _0191_ sky130_fd_sc_hd__or2_1
XFILLER_31_37 VGND VGND VPWR VPWR sky130_fd_sc_hd__decap_4
Xoutput48 net48 VGND VGND VPWR VPWR acc_out[13] sky130_fd_sc_hd__buf_2
Xoutput59 net59 VGND VGND VPWR VPWR acc_out[23] sky130_fd_sc_hd__buf_2
XPHY_EDGE_ROW_1_Right_1 VGND VGND VPWR VPWR sky130_fd_sc_hd__decap_3
Xoutput37 net37 VGND VGND VPWR VPWR a_out[3] sky130_fd_sc_hd__buf_2
XFILLER_16_115 VGND VGND VPWR VPWR sky130_fd_sc_hd__fill_2
XFILLER_16_148 VGND VGND VPWR VPWR sky130_fd_sc_hd__fill_1
X_2030_ _1139_ _1141_ _1138_ VGND VGND VPWR VPWR _1169_ sky130_fd_sc_hd__a21bo_1
XFILLER_39_218 VGND VGND VPWR VPWR sky130_fd_sc_hd__decap_6
XFILLER_47_273 VGND VGND VPWR VPWR sky130_fd_sc_hd__decap_6
X_1745_ net151 net117 VGND VGND VPWR VPWR _0884_ sky130_fd_sc_hd__nand2_1
X_1814_ _0945_ _0949_ _0946_ _0950_ VGND VGND VPWR VPWR _0953_ sky130_fd_sc_hd__or4_4
X_1676_ _0813_ _0814_ VGND VGND VPWR VPWR _0815_ sky130_fd_sc_hd__nand2_1
XFILLER_26_26 VGND VGND VPWR VPWR sky130_fd_sc_hd__fill_2
X_2228_ net285 net110 net98 _0239_ VGND VGND VPWR VPWR _0003_ sky130_fd_sc_hd__a22o_1
X_2159_ net93 _0173_ VGND VGND VPWR VPWR _0174_ sky130_fd_sc_hd__xor2_1
XFILLER_21_151 VGND VGND VPWR VPWR sky130_fd_sc_hd__decap_8
XFILLER_29_262 VGND VGND VPWR VPWR sky130_fd_sc_hd__fill_2
XFILLER_8_155 VGND VGND VPWR VPWR sky130_fd_sc_hd__decap_8
XFILLER_16_81 VGND VGND VPWR VPWR sky130_fd_sc_hd__decap_3
X_1530_ _0633_ _0634_ net108 VGND VGND VPWR VPWR _0669_ sky130_fd_sc_hd__o21a_1
X_1461_ _0331_ _0599_ VGND VGND VPWR VPWR _0600_ sky130_fd_sc_hd__xnor2_1
X_1392_ _0528_ _0530_ VGND VGND VPWR VPWR _0531_ sky130_fd_sc_hd__nand2_1
X_2013_ _1149_ _1150_ _1148_ VGND VGND VPWR VPWR _1152_ sky130_fd_sc_hd__o21ai_1
X_1728_ net208 _0795_ _0865_ _0866_ VGND VGND VPWR VPWR _0867_ sky130_fd_sc_hd__a211oi_1
XFILLER_2_309 VGND VGND VPWR VPWR sky130_fd_sc_hd__decap_8
XTAP_TAPCELL_ROW_5_136 VGND VPWR sky130_fd_sc_hd__tapvpwrvgnd_1
X_1659_ net141 net73 VGND VGND VPWR VPWR _0798_ sky130_fd_sc_hd__xor2_1
XFILLER_37_25 VGND VGND VPWR VPWR sky130_fd_sc_hd__fill_1
XFILLER_26_221 VGND VGND VPWR VPWR sky130_fd_sc_hd__fill_1
XFILLER_41_279 VGND VGND VPWR VPWR sky130_fd_sc_hd__fill_1
XFILLER_5_169 VGND VGND VPWR VPWR sky130_fd_sc_hd__fill_2
XFILLER_17_265 VPWR VGND VPWR VGND sky130_ef_sc_hd__decap_12
XTAP_TAPCELL_ROW_10_160 VGND VPWR sky130_fd_sc_hd__tapvpwrvgnd_1
X_1513_ net144 net132 net130 net149 VGND VGND VPWR VPWR _0652_ sky130_fd_sc_hd__a22oi_1
X_1375_ net97 _0512_ _0511_ VGND VGND VPWR VPWR _0514_ sky130_fd_sc_hd__a21oi_1
X_1444_ _0581_ _0582_ VGND VGND VPWR VPWR _0583_ sky130_fd_sc_hd__or2_1
XTAP_TAPCELL_ROW_2_117 VGND VPWR sky130_fd_sc_hd__tapvpwrvgnd_1
XFILLER_23_202 VPWR VGND VPWR VGND sky130_ef_sc_hd__decap_12
XTAP_TAPCELL_ROW_24_241 VGND VPWR sky130_fd_sc_hd__tapvpwrvgnd_1
XFILLER_14_213 VGND VGND VPWR VPWR sky130_fd_sc_hd__fill_1
XFILLER_14_268 VGND VGND VPWR VPWR sky130_fd_sc_hd__fill_1
XFILLER_13_82 VGND VGND VPWR VPWR sky130_fd_sc_hd__decap_6
Xfanout94 _0339_ VGND VGND VPWR VPWR net94 sky130_fd_sc_hd__buf_4
XTAP_TAPCELL_ROW_47_366 VGND VPWR sky130_fd_sc_hd__tapvpwrvgnd_1
X_1993_ _1102_ _1104_ _1101_ VGND VGND VPWR VPWR _1132_ sky130_fd_sc_hd__o21ba_1
X_1427_ _0562_ _0564_ _0510_ _0561_ VGND VGND VPWR VPWR _0566_ sky130_fd_sc_hd__o211a_1
X_1358_ _0338_ _0496_ VGND VGND VPWR VPWR _0497_ sky130_fd_sc_hd__xor2_1
X_1289_ _0426_ _0427_ VGND VGND VPWR VPWR _0428_ sky130_fd_sc_hd__nor2_1
XTAP_TAPCELL_ROW_21_222 VGND VPWR sky130_fd_sc_hd__tapvpwrvgnd_1
XTAP_TAPCELL_ROW_44_347 VGND VPWR sky130_fd_sc_hd__tapvpwrvgnd_1
XFILLER_24_70 VGND VGND VPWR VPWR sky130_fd_sc_hd__fill_1
XFILLER_6_231 VGND VGND VPWR VPWR sky130_fd_sc_hd__decap_8
XFILLER_6_253 VGND VGND VPWR VPWR sky130_fd_sc_hd__fill_2
XFILLER_10_271 VGND VGND VPWR VPWR sky130_fd_sc_hd__fill_2
XFILLER_37_124 VGND VGND VPWR VPWR sky130_fd_sc_hd__decap_4
X_2261_ _0870_ _1089_ _1129_ VGND VGND VPWR VPWR _0263_ sky130_fd_sc_hd__or3_1
X_1212_ net65 _0344_ VGND VGND VPWR VPWR _0351_ sky130_fd_sc_hd__nor2_1
X_2330_ net273 net113 _0315_ net101 VGND VGND VPWR VPWR _0029_ sky130_fd_sc_hd__a22o_1
X_2192_ _0454_ _0206_ VGND VGND VPWR VPWR _0207_ sky130_fd_sc_hd__nor2_1
X_1976_ _0847_ _0854_ _0853_ VGND VGND VPWR VPWR _1115_ sky130_fd_sc_hd__a21bo_1
Xhold59 net32 VGND VGND VPWR VPWR net250 sky130_fd_sc_hd__dlygate4sd3_1
XFILLER_19_113 VGND VGND VPWR VPWR sky130_fd_sc_hd__fill_1
XFILLER_19_157 VGND VGND VPWR VPWR sky130_fd_sc_hd__decap_3
X_1830_ _0882_ _0883_ _0888_ VGND VGND VPWR VPWR _0969_ sky130_fd_sc_hd__a21o_1
X_1761_ _0895_ _0899_ VGND VGND VPWR VPWR _0900_ sky130_fd_sc_hd__xnor2_1
X_1692_ _0827_ _0829_ _0795_ _0796_ VGND VGND VPWR VPWR _0831_ sky130_fd_sc_hd__o211ai_2
X_2313_ net282 net114 _0302_ net102 VGND VGND VPWR VPWR _0025_ sky130_fd_sc_hd__a22o_1
X_2175_ _0186_ _0189_ VGND VGND VPWR VPWR _0190_ sky130_fd_sc_hd__nand2_1
X_2244_ net74 net111 net99 _0250_ VGND VGND VPWR VPWR _0008_ sky130_fd_sc_hd__a22o_1
XFILLER_40_108 VGND VGND VPWR VPWR sky130_fd_sc_hd__decap_8
XFILLER_18_190 VGND VGND VPWR VPWR sky130_fd_sc_hd__decap_6
X_1959_ _0833_ _0835_ _0834_ VGND VGND VPWR VPWR _1098_ sky130_fd_sc_hd__o21ba_1
Xoutput49 net49 VGND VGND VPWR VPWR acc_out[14] sky130_fd_sc_hd__buf_2
Xoutput38 net38 VGND VGND VPWR VPWR a_out[4] sky130_fd_sc_hd__buf_2
XFILLER_31_119 VGND VGND VPWR VPWR sky130_fd_sc_hd__fill_1
Xclkbuf_0_clk clk VGND VGND VPWR VPWR clknet_0_clk sky130_fd_sc_hd__clkbuf_16
XTAP_TAPCELL_ROW_17_199 VGND VPWR sky130_fd_sc_hd__tapvpwrvgnd_1
XFILLER_30_185 VGND VGND VPWR VPWR sky130_fd_sc_hd__decap_8
XFILLER_30_174 VGND VGND VPWR VPWR sky130_fd_sc_hd__fill_2
XFILLER_30_141 VGND VGND VPWR VPWR sky130_fd_sc_hd__decap_4
X_1813_ _0949_ _0950_ VGND VGND VPWR VPWR _0952_ sky130_fd_sc_hd__or2_1
X_1744_ _0880_ _0881_ _0874_ net196 VGND VGND VPWR VPWR _0883_ sky130_fd_sc_hd__o211ai_2
XPHY_EDGE_ROW_15_Right_15 VGND VGND VPWR VPWR sky130_fd_sc_hd__decap_3
X_1675_ _0725_ _0727_ VGND VGND VPWR VPWR _0814_ sky130_fd_sc_hd__xnor2_1
X_2089_ _0680_ _0094_ _0095_ VGND VGND VPWR VPWR _0104_ sky130_fd_sc_hd__a21o_1
XFILLER_38_285 VGND VGND VPWR VPWR sky130_fd_sc_hd__decap_8
XPHY_EDGE_ROW_24_Right_24 VGND VGND VPWR VPWR sky130_fd_sc_hd__decap_3
X_2227_ _1070_ net84 _0238_ net88 VGND VGND VPWR VPWR _0239_ sky130_fd_sc_hd__a31o_1
X_2158_ _0166_ _0171_ VGND VGND VPWR VPWR _0173_ sky130_fd_sc_hd__xnor2_1
XFILLER_42_26 VGND VGND VPWR VPWR sky130_fd_sc_hd__fill_2
XPHY_EDGE_ROW_33_Right_33 VGND VGND VPWR VPWR sky130_fd_sc_hd__decap_3
XFILLER_44_211 VPWR VGND VPWR VGND sky130_ef_sc_hd__decap_12
XPHY_EDGE_ROW_42_Right_42 VGND VGND VPWR VPWR sky130_fd_sc_hd__decap_3
XFILLER_29_296 VGND VGND VPWR VPWR sky130_fd_sc_hd__fill_1
XFILLER_32_81 VGND VGND VPWR VPWR sky130_fd_sc_hd__decap_3
XFILLER_12_141 VPWR VGND VPWR VGND sky130_ef_sc_hd__decap_12
XFILLER_12_185 VGND VGND VPWR VPWR sky130_fd_sc_hd__decap_8
X_1460_ net153 net127 VGND VGND VPWR VPWR _0599_ sky130_fd_sc_hd__nand2_1
X_1391_ _0517_ _0524_ _0528_ _0529_ VGND VGND VPWR VPWR _0530_ sky130_fd_sc_hd__o211ai_2
X_2012_ _1148_ _1149_ _1150_ VGND VGND VPWR VPWR _1151_ sky130_fd_sc_hd__or3_1
XFILLER_35_211 VGND VGND VPWR VPWR sky130_fd_sc_hd__decap_6
XPHY_EDGE_ROW_19_Left_69 VGND VGND VPWR VPWR sky130_fd_sc_hd__decap_3
X_1727_ _0863_ _0864_ _0768_ _0771_ VGND VGND VPWR VPWR _0866_ sky130_fd_sc_hd__o211a_1
XTAP_TAPCELL_ROW_13_180 VGND VPWR sky130_fd_sc_hd__tapvpwrvgnd_1
X_1658_ net141 net73 VGND VGND VPWR VPWR _0797_ sky130_fd_sc_hd__and2_1
XTAP_TAPCELL_ROW_5_137 VGND VPWR sky130_fd_sc_hd__tapvpwrvgnd_1
X_1589_ _0725_ _0726_ _0724_ VGND VGND VPWR VPWR _0728_ sky130_fd_sc_hd__o21ba_1
XFILLER_41_225 VGND VGND VPWR VPWR sky130_fd_sc_hd__decap_6
XFILLER_26_288 VGND VGND VPWR VPWR sky130_fd_sc_hd__fill_1
XFILLER_32_236 VGND VGND VPWR VPWR sky130_fd_sc_hd__fill_1
XFILLER_32_225 VGND VGND VPWR VPWR sky130_fd_sc_hd__decap_4
XFILLER_17_277 VGND VGND VPWR VPWR sky130_fd_sc_hd__decap_3
X_1512_ net142 _0324_ VGND VGND VPWR VPWR _0651_ sky130_fd_sc_hd__nand2_1
XTAP_TAPCELL_ROW_10_161 VGND VPWR sky130_fd_sc_hd__tapvpwrvgnd_1
X_1374_ _0511_ _0512_ VGND VGND VPWR VPWR _0513_ sky130_fd_sc_hd__nand2b_1
X_1443_ _0560_ _0569_ VGND VGND VPWR VPWR _0582_ sky130_fd_sc_hd__xor2_1
XFILLER_4_85 VGND VGND VPWR VPWR sky130_fd_sc_hd__fill_1
XTAP_TAPCELL_ROW_2_118 VGND VPWR sky130_fd_sc_hd__tapvpwrvgnd_1
XFILLER_23_214 VGND VGND VPWR VPWR sky130_fd_sc_hd__decap_8
XFILLER_23_17 VGND VGND VPWR VPWR sky130_fd_sc_hd__fill_1
XFILLER_23_28 VGND VGND VPWR VPWR sky130_fd_sc_hd__decap_4
XFILLER_46_317 VGND VGND VPWR VPWR sky130_fd_sc_hd__decap_3
XTAP_TAPCELL_ROW_24_242 VGND VPWR sky130_fd_sc_hd__tapvpwrvgnd_1
Xfanout95 net97 VGND VGND VPWR VPWR net95 sky130_fd_sc_hd__buf_2
Xfanout84 _0228_ VGND VGND VPWR VPWR net84 sky130_fd_sc_hd__buf_4
XFILLER_49_166 VGND VGND VPWR VPWR sky130_fd_sc_hd__fill_2
XTAP_TAPCELL_ROW_47_367 VGND VPWR sky130_fd_sc_hd__tapvpwrvgnd_1
X_1992_ _1097_ _1099_ _1096_ VGND VGND VPWR VPWR _1131_ sky130_fd_sc_hd__a21o_1
XFILLER_20_228 VGND VGND VPWR VPWR sky130_fd_sc_hd__decap_3
XFILLER_20_239 VGND VGND VPWR VPWR sky130_fd_sc_hd__fill_1
X_1426_ net106 _0562_ _0563_ VGND VGND VPWR VPWR _0565_ sky130_fd_sc_hd__or3_1
XFILLER_28_317 VGND VGND VPWR VPWR sky130_fd_sc_hd__decap_3
X_1288_ _0411_ _0422_ _0425_ VGND VGND VPWR VPWR _0427_ sky130_fd_sc_hd__nor3_1
X_1357_ _0335_ _0459_ _0328_ VGND VGND VPWR VPWR _0496_ sky130_fd_sc_hd__a21oi_1
XTAP_TAPCELL_ROW_21_223 VGND VPWR sky130_fd_sc_hd__tapvpwrvgnd_1
XFILLER_46_158 VGND VGND VPWR VPWR sky130_fd_sc_hd__decap_3
XFILLER_34_309 VGND VGND VPWR VPWR sky130_fd_sc_hd__decap_3
XTAP_TAPCELL_ROW_44_348 VGND VPWR sky130_fd_sc_hd__tapvpwrvgnd_1
XFILLER_41_7 VPWR VGND VPWR VGND sky130_ef_sc_hd__decap_12
XFILLER_40_70 VGND VGND VPWR VPWR sky130_fd_sc_hd__fill_1
X_2260_ net47 net112 net100 _0262_ VGND VGND VPWR VPWR _0012_ sky130_fd_sc_hd__a22o_1
X_1211_ net172 net121 net65 VGND VGND VPWR VPWR _0350_ sky130_fd_sc_hd__and3_1
X_2191_ _0434_ _0453_ VGND VGND VPWR VPWR _0206_ sky130_fd_sc_hd__and2b_1
X_1975_ _1111_ _1112_ _1105_ VGND VGND VPWR VPWR _1114_ sky130_fd_sc_hd__a21o_1
XFILLER_20_29 VGND VGND VPWR VPWR sky130_fd_sc_hd__fill_2
X_1409_ _0481_ _0484_ _0546_ VGND VGND VPWR VPWR _0548_ sky130_fd_sc_hd__nor3_1
X_2389_ clknet_2_2__leaf_clk _0029_ net137 VGND VGND VPWR VPWR net65 sky130_fd_sc_hd__dfrtp_1
XPHY_EDGE_ROW_7_Left_57 VGND VGND VPWR VPWR sky130_fd_sc_hd__decap_3
XFILLER_19_71 VGND VGND VPWR VPWR sky130_fd_sc_hd__fill_2
XFILLER_35_70 VGND VGND VPWR VPWR sky130_fd_sc_hd__fill_2
X_1760_ _0896_ _0897_ VGND VGND VPWR VPWR _0899_ sky130_fd_sc_hd__xor2_1
X_1691_ _0815_ _0822_ _0827_ _0828_ VGND VGND VPWR VPWR _0830_ sky130_fd_sc_hd__a211o_1
X_2312_ net85 _0301_ net89 VGND VGND VPWR VPWR _0302_ sky130_fd_sc_hd__a21o_1
X_2243_ _1084_ net84 _0249_ net88 VGND VGND VPWR VPWR _0250_ sky130_fd_sc_hd__a31o_1
X_2174_ _0161_ _0187_ VGND VGND VPWR VPWR _0189_ sky130_fd_sc_hd__xor2_1
XPHY_EDGE_ROW_49_Left_99 VGND VGND VPWR VPWR sky130_fd_sc_hd__decap_3
X_1958_ _1090_ _1095_ VGND VGND VPWR VPWR _1097_ sky130_fd_sc_hd__xnor2_1
X_1889_ net168 net118 net66 VGND VGND VPWR VPWR _1028_ sky130_fd_sc_hd__and3_1
Xoutput39 net39 VGND VGND VPWR VPWR a_out[5] sky130_fd_sc_hd__buf_2
Xoutput28 net28 VGND VGND VPWR VPWR a_out[0] sky130_fd_sc_hd__buf_2
XFILLER_48_209 VPWR VGND VPWR VGND sky130_ef_sc_hd__decap_12
XFILLER_0_249 VGND VGND VPWR VPWR sky130_fd_sc_hd__decap_3
XFILLER_16_128 VGND VGND VPWR VPWR sky130_fd_sc_hd__decap_6
XFILLER_16_139 VGND VGND VPWR VPWR sky130_fd_sc_hd__fill_1
XFILLER_21_94 VGND VGND VPWR VPWR sky130_fd_sc_hd__decap_8
XFILLER_39_209 VGND VGND VPWR VPWR sky130_fd_sc_hd__fill_1
XFILLER_15_150 VGND VGND VPWR VPWR sky130_fd_sc_hd__decap_4
XFILLER_15_161 VGND VGND VPWR VPWR sky130_fd_sc_hd__decap_6
XFILLER_7_74 VGND VGND VPWR VPWR sky130_fd_sc_hd__fill_1
X_1743_ _0874_ net195 _0880_ _0881_ VGND VGND VPWR VPWR _0882_ sky130_fd_sc_hd__a211o_1
X_1674_ net151 net187 _0804_ _0803_ VGND VGND VPWR VPWR _0813_ sky130_fd_sc_hd__a31o_1
X_1812_ _0950_ VGND VGND VPWR VPWR _0951_ sky130_fd_sc_hd__inv_2
X_2226_ _1062_ _1069_ VGND VGND VPWR VPWR _0238_ sky130_fd_sc_hd__or2_1
X_2088_ _0100_ _0101_ VGND VGND VPWR VPWR _0103_ sky130_fd_sc_hd__xnor2_1
X_2157_ _0171_ _0166_ VGND VGND VPWR VPWR _0172_ sky130_fd_sc_hd__and2b_1
XFILLER_44_223 VGND VGND VPWR VPWR sky130_fd_sc_hd__decap_6
XFILLER_44_201 VGND VGND VPWR VPWR sky130_fd_sc_hd__fill_2
XFILLER_29_231 VGND VGND VPWR VPWR sky130_fd_sc_hd__decap_8
XFILLER_8_102 VGND VGND VPWR VPWR sky130_fd_sc_hd__fill_2
XFILLER_12_153 VGND VGND VPWR VPWR sky130_fd_sc_hd__decap_4
XFILLER_12_164 VPWR VGND VPWR VGND sky130_ef_sc_hd__decap_12
X_1390_ _0504_ _0515_ _0527_ VGND VGND VPWR VPWR _0529_ sky130_fd_sc_hd__or3_1
X_2011_ net171 net128 net49 VGND VGND VPWR VPWR _1150_ sky130_fd_sc_hd__a21oi_1
XFILLER_35_289 VGND VGND VPWR VPWR sky130_fd_sc_hd__fill_1
XFILLER_35_278 VGND VGND VPWR VPWR sky130_fd_sc_hd__fill_2
XFILLER_12_19 VGND VGND VPWR VPWR sky130_fd_sc_hd__fill_1
XTAP_TAPCELL_ROW_13_181 VGND VPWR sky130_fd_sc_hd__tapvpwrvgnd_1
X_1726_ _0768_ _0771_ _0863_ _0864_ VGND VGND VPWR VPWR _0865_ sky130_fd_sc_hd__a211oi_2
X_1657_ _0794_ _0793_ _0722_ _0729_ VGND VGND VPWR VPWR _0796_ sky130_fd_sc_hd__a211o_1
X_1588_ _0724_ _0726_ VGND VGND VPWR VPWR _0727_ sky130_fd_sc_hd__nor2_1
X_2209_ _0222_ _0223_ VGND VGND VPWR VPWR _0224_ sky130_fd_sc_hd__xnor2_1
XPHY_EDGE_ROW_36_Left_86 VGND VGND VPWR VPWR sky130_fd_sc_hd__decap_3
Xclkbuf_2_0__f_clk clknet_0_clk VGND VGND VPWR VPWR clknet_2_0__leaf_clk sky130_fd_sc_hd__clkbuf_16
X_1511_ net149 net144 net132 net130 VGND VGND VPWR VPWR _0650_ sky130_fd_sc_hd__and4_1
X_1442_ _0579_ _0580_ VGND VGND VPWR VPWR _0581_ sky130_fd_sc_hd__nand2_1
XTAP_TAPCELL_ROW_10_162 VGND VPWR sky130_fd_sc_hd__tapvpwrvgnd_1
X_1373_ _0491_ _0506_ _0507_ _0509_ VGND VGND VPWR VPWR _0512_ sky130_fd_sc_hd__a211o_1
XFILLER_4_97 VGND VGND VPWR VPWR sky130_fd_sc_hd__fill_2
XTAP_TAPCELL_ROW_2_119 VGND VPWR sky130_fd_sc_hd__tapvpwrvgnd_1
XFILLER_23_259 VGND VGND VPWR VPWR sky130_fd_sc_hd__decap_3
XTAP_TAPCELL_ROW_33_287 VGND VPWR sky130_fd_sc_hd__tapvpwrvgnd_1
XFILLER_31_281 VGND VGND VPWR VPWR sky130_fd_sc_hd__fill_1
XFILLER_48_15 VPWR VGND VPWR VGND sky130_ef_sc_hd__decap_12
X_1709_ net225 net130 net47 VGND VGND VPWR VPWR _0848_ sky130_fd_sc_hd__and3_1
XFILLER_46_307 VGND VGND VPWR VPWR sky130_fd_sc_hd__fill_1
XFILLER_14_226 VGND VGND VPWR VPWR sky130_fd_sc_hd__decap_8
Xfanout85 _0228_ VGND VGND VPWR VPWR net85 sky130_fd_sc_hd__clkbuf_2
Xfanout96 net97 VGND VGND VPWR VPWR net96 sky130_fd_sc_hd__buf_2
XFILLER_13_62 VGND VGND VPWR VPWR sky130_fd_sc_hd__decap_4
XFILLER_37_318 VGND VGND VPWR VPWR sky130_fd_sc_hd__fill_2
XTAP_TAPCELL_ROW_47_368 VGND VPWR sky130_fd_sc_hd__tapvpwrvgnd_1
X_1991_ _1129_ VGND VGND VPWR VPWR _1130_ sky130_fd_sc_hd__inv_2
XFILLER_9_230 VGND VGND VPWR VPWR sky130_fd_sc_hd__decap_8
X_1425_ net107 _0562_ _0563_ VGND VGND VPWR VPWR _0564_ sky130_fd_sc_hd__nor3_1
X_1356_ net97 _0494_ _0492_ VGND VGND VPWR VPWR _0495_ sky130_fd_sc_hd__a21oi_2
X_1287_ _0422_ _0425_ _0411_ VGND VGND VPWR VPWR _0426_ sky130_fd_sc_hd__o21a_1
XFILLER_34_39 VGND VGND VPWR VPWR sky130_fd_sc_hd__fill_1
XTAP_TAPCELL_ROW_21_224 VGND VPWR sky130_fd_sc_hd__tapvpwrvgnd_1
XTAP_TAPCELL_ROW_44_349 VGND VPWR sky130_fd_sc_hd__tapvpwrvgnd_1
XFILLER_6_211 VPWR VGND VPWR VGND sky130_ef_sc_hd__decap_12
XFILLER_10_251 VGND VGND VPWR VPWR sky130_fd_sc_hd__fill_1
X_1210_ _0347_ _0348_ VGND VGND VPWR VPWR _0349_ sky130_fd_sc_hd__nor2_1
X_2190_ _0203_ _0204_ VGND VGND VPWR VPWR _0205_ sky130_fd_sc_hd__or2_1
X_1974_ _1105_ _1111_ _1112_ VGND VGND VPWR VPWR _1113_ sky130_fd_sc_hd__nand3_1
XPHY_EDGE_ROW_23_Left_73 VGND VGND VPWR VPWR sky130_fd_sc_hd__decap_3
XFILLER_29_17 VGND VGND VPWR VPWR sky130_fd_sc_hd__fill_1
X_2388_ clknet_2_2__leaf_clk _0028_ net138 VGND VGND VPWR VPWR net64 sky130_fd_sc_hd__dfrtp_1
X_1408_ _0481_ _0484_ _0546_ VGND VGND VPWR VPWR _0547_ sky130_fd_sc_hd__o21a_1
XFILLER_45_38 VGND VGND VPWR VPWR sky130_fd_sc_hd__fill_1
X_1339_ _0473_ _0477_ VGND VGND VPWR VPWR _0478_ sky130_fd_sc_hd__and2_1
XFILLER_10_85 VGND VGND VPWR VPWR sky130_fd_sc_hd__fill_2
XFILLER_42_195 VGND VGND VPWR VPWR sky130_fd_sc_hd__fill_1
XFILLER_42_162 VGND VGND VPWR VPWR sky130_fd_sc_hd__decap_4
XTAP_TAPCELL_ROW_40_330 VGND VPWR sky130_fd_sc_hd__tapvpwrvgnd_1
X_1690_ _0815_ _0822_ _0827_ _0828_ VGND VGND VPWR VPWR _0829_ sky130_fd_sc_hd__a211oi_1
X_2242_ _1081_ _1082_ VGND VGND VPWR VPWR _0249_ sky130_fd_sc_hd__nand2_1
X_2311_ _0164_ _0300_ VGND VGND VPWR VPWR _0301_ sky130_fd_sc_hd__xnor2_1
X_2173_ _0161_ _0187_ VGND VGND VPWR VPWR _0188_ sky130_fd_sc_hd__and2_1
X_1957_ _1090_ _1095_ VGND VGND VPWR VPWR _1096_ sky130_fd_sc_hd__and2b_1
Xoutput29 net29 VGND VGND VPWR VPWR a_out[10] sky130_fd_sc_hd__buf_2
X_1888_ _0989_ _0990_ net164 net118 VGND VGND VPWR VPWR _1027_ sky130_fd_sc_hd__a2bb2o_1
XFILLER_24_195 VGND VGND VPWR VPWR sky130_fd_sc_hd__fill_1
XFILLER_46_70 VGND VGND VPWR VPWR sky130_fd_sc_hd__decap_6
XFILLER_30_165 VGND VGND VPWR VPWR sky130_fd_sc_hd__decap_4
X_1811_ _0831_ net202 _0943_ VGND VGND VPWR VPWR _0950_ sky130_fd_sc_hd__a21oi_1
X_1673_ _0742_ _0810_ _0811_ VGND VGND VPWR VPWR _0812_ sky130_fd_sc_hd__and3_4
X_1742_ _0878_ _0879_ _0877_ VGND VGND VPWR VPWR _0881_ sky130_fd_sc_hd__o21a_1
X_2225_ net276 net110 net98 _0237_ VGND VGND VPWR VPWR _0002_ sky130_fd_sc_hd__a22o_1
X_2087_ _0101_ _0100_ VGND VGND VPWR VPWR _0102_ sky130_fd_sc_hd__nand2b_1
XPHY_EDGE_ROW_5_Right_5 VGND VGND VPWR VPWR sky130_fd_sc_hd__decap_3
X_2156_ _0167_ _0168_ _0170_ VGND VGND VPWR VPWR _0171_ sky130_fd_sc_hd__o21a_1
XPHY_EDGE_ROW_10_Left_60 VGND VGND VPWR VPWR sky130_fd_sc_hd__decap_3
XFILLER_12_110 VGND VGND VPWR VPWR sky130_fd_sc_hd__decap_6
XFILLER_12_121 VGND VGND VPWR VPWR sky130_fd_sc_hd__decap_6
XFILLER_12_176 VGND VGND VPWR VPWR sky130_fd_sc_hd__fill_2
XFILLER_16_40 VGND VGND VPWR VPWR sky130_fd_sc_hd__fill_1
X_2010_ net171 net128 net49 VGND VGND VPWR VPWR _1149_ sky130_fd_sc_hd__and3_1
XFILLER_35_235 VGND VGND VPWR VPWR sky130_fd_sc_hd__decap_6
X_1725_ _0860_ _0862_ _0788_ _0791_ VGND VGND VPWR VPWR _0864_ sky130_fd_sc_hd__o211a_1
X_1656_ _0722_ _0729_ _0793_ _0794_ VGND VGND VPWR VPWR _0795_ sky130_fd_sc_hd__o211ai_4
X_1587_ net143 net189 net187 net147 VGND VGND VPWR VPWR _0726_ sky130_fd_sc_hd__a22oi_1
X_2208_ _0403_ _0404_ net92 VGND VGND VPWR VPWR _0223_ sky130_fd_sc_hd__mux2_1
X_2139_ _0152_ _0153_ VGND VGND VPWR VPWR _0154_ sky130_fd_sc_hd__or2_1
XFILLER_41_238 VGND VGND VPWR VPWR sky130_fd_sc_hd__fill_1
XFILLER_49_305 VGND VGND VPWR VPWR sky130_fd_sc_hd__decap_3
XFILLER_27_83 VGND VGND VPWR VPWR sky130_fd_sc_hd__fill_2
X_1510_ _0646_ _0647_ VGND VGND VPWR VPWR _0649_ sky130_fd_sc_hd__xnor2_1
X_1441_ _0573_ _0578_ VGND VGND VPWR VPWR _0580_ sky130_fd_sc_hd__nand2b_1
XTAP_TAPCELL_ROW_10_163 VGND VPWR sky130_fd_sc_hd__tapvpwrvgnd_1
X_1372_ _0507_ _0509_ _0491_ _0506_ VGND VGND VPWR VPWR _0511_ sky130_fd_sc_hd__o211a_1
XFILLER_31_260 VGND VGND VPWR VPWR sky130_fd_sc_hd__fill_2
X_1708_ _0845_ _0846_ VGND VGND VPWR VPWR _0847_ sky130_fd_sc_hd__xnor2_1
XTAP_TAPCELL_ROW_33_288 VGND VPWR sky130_fd_sc_hd__tapvpwrvgnd_1
XFILLER_48_27 VGND VGND VPWR VPWR sky130_fd_sc_hd__fill_1
X_1639_ _0776_ _0777_ VGND VGND VPWR VPWR _0778_ sky130_fd_sc_hd__xnor2_1
Xfanout97 _0342_ VGND VGND VPWR VPWR net97 sky130_fd_sc_hd__clkbuf_4
XFILLER_13_52 VGND VGND VPWR VPWR sky130_fd_sc_hd__decap_4
Xfanout86 _0228_ VGND VGND VPWR VPWR net86 sky130_fd_sc_hd__buf_2
XFILLER_22_260 VGND VGND VPWR VPWR sky130_fd_sc_hd__fill_1
XFILLER_38_71 VPWR VGND VPWR VGND sky130_ef_sc_hd__decap_12
X_1990_ _1127_ _1128_ VGND VGND VPWR VPWR _1129_ sky130_fd_sc_hd__and2b_1
X_1424_ net174 net124 net53 VGND VGND VPWR VPWR _0563_ sky130_fd_sc_hd__a21oi_1
X_1355_ _0492_ _0493_ VGND VGND VPWR VPWR _0494_ sky130_fd_sc_hd__nor2_1
XTAP_TAPCELL_ROW_38_314 VGND VPWR sky130_fd_sc_hd__tapvpwrvgnd_1
X_1286_ net94 _0424_ VGND VGND VPWR VPWR _0425_ sky130_fd_sc_hd__nor2_1
XTAP_TAPCELL_ROW_21_225 VGND VPWR sky130_fd_sc_hd__tapvpwrvgnd_1
XFILLER_10_263 VGND VGND VPWR VPWR sky130_fd_sc_hd__decap_8
XFILLER_49_81 VGND VGND VPWR VPWR sky130_fd_sc_hd__decap_3
XFILLER_40_83 VGND VGND VPWR VPWR sky130_fd_sc_hd__fill_1
XFILLER_1_55 VGND VGND VPWR VPWR sky130_fd_sc_hd__fill_1
X_1973_ _1109_ _1110_ _0848_ _0850_ VGND VGND VPWR VPWR _1112_ sky130_fd_sc_hd__a211o_1
X_1338_ _0474_ _0476_ VGND VGND VPWR VPWR _0477_ sky130_fd_sc_hd__nand2b_1
X_2387_ clknet_2_2__leaf_clk _0027_ net138 VGND VGND VPWR VPWR net63 sky130_fd_sc_hd__dfrtp_1
X_1407_ _0340_ _0544_ VGND VGND VPWR VPWR _0546_ sky130_fd_sc_hd__xnor2_1
XFILLER_36_193 VGND VGND VPWR VPWR sky130_fd_sc_hd__decap_3
X_1269_ _0386_ _0390_ _0406_ VGND VGND VPWR VPWR _0408_ sky130_fd_sc_hd__or3_1
XPHY_EDGE_ROW_40_Left_90 VGND VGND VPWR VPWR sky130_fd_sc_hd__decap_3
XFILLER_19_149 VGND VGND VPWR VPWR sky130_fd_sc_hd__decap_8
XFILLER_42_141 VGND VGND VPWR VPWR sky130_fd_sc_hd__decap_6
X_2241_ net73 net110 net98 _0248_ VGND VGND VPWR VPWR _0007_ sky130_fd_sc_hd__a22o_1
X_2172_ _0182_ _0183_ VGND VGND VPWR VPWR _0187_ sky130_fd_sc_hd__xnor2_1
X_2310_ _0555_ _0146_ VGND VGND VPWR VPWR _0300_ sky130_fd_sc_hd__nand2_1
XFILLER_33_130 VGND VGND VPWR VPWR sky130_fd_sc_hd__decap_3
X_1956_ _1091_ _1094_ VGND VGND VPWR VPWR _1095_ sky130_fd_sc_hd__xnor2_1
X_1887_ _0994_ _0995_ _1000_ VGND VGND VPWR VPWR _1026_ sky130_fd_sc_hd__a21o_1
XFILLER_8_307 VGND VGND VPWR VPWR sky130_fd_sc_hd__fill_1
XFILLER_21_41 VGND VGND VPWR VPWR sky130_fd_sc_hd__decap_8
XFILLER_21_85 VGND VGND VPWR VPWR sky130_fd_sc_hd__decap_4
X_1810_ _0831_ _0948_ _0943_ VGND VGND VPWR VPWR _0949_ sky130_fd_sc_hd__and3_1
X_1741_ _0877_ _0878_ _0879_ VGND VGND VPWR VPWR _0880_ sky130_fd_sc_hd__nor3_1
X_1672_ _0739_ _0741_ _0740_ VGND VGND VPWR VPWR _0811_ sky130_fd_sc_hd__a21o_1
XFILLER_38_266 VGND VGND VPWR VPWR sky130_fd_sc_hd__decap_3
XFILLER_38_244 VGND VGND VPWR VPWR sky130_fd_sc_hd__fill_2
XFILLER_38_211 VGND VGND VPWR VPWR sky130_fd_sc_hd__fill_2
X_2224_ net84 _0236_ net88 VGND VGND VPWR VPWR _0237_ sky130_fd_sc_hd__a21o_1
X_2155_ net94 _0169_ VGND VGND VPWR VPWR _0170_ sky130_fd_sc_hd__or2_1
X_2086_ _1171_ _1173_ _1172_ VGND VGND VPWR VPWR _0101_ sky130_fd_sc_hd__o21ba_1
XFILLER_42_18 VGND VGND VPWR VPWR sky130_fd_sc_hd__decap_8
X_1939_ _1073_ _1075_ _1059_ VGND VGND VPWR VPWR _1078_ sky130_fd_sc_hd__o21a_1
XFILLER_44_258 VPWR VGND VPWR VGND sky130_ef_sc_hd__decap_12
XFILLER_44_236 VGND VGND VPWR VPWR sky130_fd_sc_hd__decap_6
XPHY_EDGE_ROW_11_Right_11 VGND VGND VPWR VPWR sky130_fd_sc_hd__decap_3
XFILLER_12_100 VGND VGND VPWR VPWR sky130_fd_sc_hd__decap_6
XFILLER_16_85 VGND VGND VPWR VPWR sky130_fd_sc_hd__decap_6
XFILLER_16_96 VGND VGND VPWR VPWR sky130_fd_sc_hd__fill_1
XFILLER_32_95 VGND VGND VPWR VPWR sky130_fd_sc_hd__decap_3
XPHY_EDGE_ROW_20_Right_20 VGND VGND VPWR VPWR sky130_fd_sc_hd__decap_3
X_1724_ _0788_ _0791_ _0860_ _0862_ VGND VGND VPWR VPWR _0863_ sky130_fd_sc_hd__a211oi_2
X_1655_ net201 _0792_ _0758_ _0761_ VGND VGND VPWR VPWR _0794_ sky130_fd_sc_hd__o211ai_2
X_1586_ net141 _0320_ VGND VGND VPWR VPWR _0725_ sky130_fd_sc_hd__nand2_1
X_2069_ _1125_ _0082_ VGND VGND VPWR VPWR _0084_ sky130_fd_sc_hd__nand2_1
X_2207_ _0217_ _0221_ VGND VGND VPWR VPWR _0222_ sky130_fd_sc_hd__xnor2_1
X_2138_ _0538_ _0540_ _0151_ VGND VGND VPWR VPWR _0153_ sky130_fd_sc_hd__nor3_1
XFILLER_49_317 VGND VGND VPWR VPWR sky130_fd_sc_hd__decap_3
XFILLER_32_217 VGND VGND VPWR VPWR sky130_fd_sc_hd__fill_1
XTAP_TAPCELL_ROW_10_164 VGND VPWR sky130_fd_sc_hd__tapvpwrvgnd_1
X_1371_ net106 _0507_ _0508_ VGND VGND VPWR VPWR _0510_ sky130_fd_sc_hd__or3_1
X_1440_ _0578_ _0573_ VGND VGND VPWR VPWR _0579_ sky130_fd_sc_hd__nand2b_1
XFILLER_4_195 VGND VGND VPWR VPWR sky130_fd_sc_hd__fill_1
XTAP_TAPCELL_ROW_33_289 VGND VPWR sky130_fd_sc_hd__tapvpwrvgnd_1
X_1707_ net152 net179 VGND VGND VPWR VPWR _0846_ sky130_fd_sc_hd__nand2_1
X_1638_ net152 net181 VGND VGND VPWR VPWR _0777_ sky130_fd_sc_hd__nand2_1
XFILLER_46_309 VGND VGND VPWR VPWR sky130_fd_sc_hd__decap_8
X_1569_ _0704_ _0707_ VGND VGND VPWR VPWR _0708_ sky130_fd_sc_hd__nor2_1
Xfanout87 _0228_ VGND VGND VPWR VPWR net87 sky130_fd_sc_hd__dlymetal6s2s_1
Xfanout98 net99 VGND VGND VPWR VPWR net98 sky130_fd_sc_hd__buf_2
XFILLER_22_283 VGND VGND VPWR VPWR sky130_fd_sc_hd__fill_2
XFILLER_38_94 VGND VGND VPWR VPWR sky130_fd_sc_hd__fill_2
XFILLER_38_83 VGND VGND VPWR VPWR sky130_fd_sc_hd__fill_1
XFILLER_48_3 VPWR VGND VPWR VGND sky130_ef_sc_hd__decap_12
X_1423_ net174 net124 net53 VGND VGND VPWR VPWR _0562_ sky130_fd_sc_hd__and3_1
X_1354_ _0476_ _0487_ _0488_ _0490_ VGND VGND VPWR VPWR _0493_ sky130_fd_sc_hd__a211oi_1
X_1285_ _0422_ _0423_ VGND VGND VPWR VPWR _0424_ sky130_fd_sc_hd__or2_1
XTAP_TAPCELL_ROW_38_315 VGND VPWR sky130_fd_sc_hd__tapvpwrvgnd_1
XFILLER_24_85 VGND VGND VPWR VPWR sky130_fd_sc_hd__fill_1
XFILLER_40_62 VGND VGND VPWR VPWR sky130_fd_sc_hd__decap_8
XFILLER_10_253 VGND VGND VPWR VPWR sky130_fd_sc_hd__decap_4
XFILLER_10_297 VGND VGND VPWR VPWR sky130_fd_sc_hd__decap_3
X_1972_ _0848_ _0850_ _1109_ _1110_ VGND VGND VPWR VPWR _1111_ sky130_fd_sc_hd__o211ai_2
XPHY_EDGE_ROW_49_Right_49 VGND VGND VPWR VPWR sky130_fd_sc_hd__decap_3
XFILLER_45_18 VPWR VGND VPWR VGND sky130_ef_sc_hd__decap_12
X_1337_ net106 _0474_ _0475_ VGND VGND VPWR VPWR _0476_ sky130_fd_sc_hd__or3_1
X_2386_ clknet_2_2__leaf_clk _0026_ net138 VGND VGND VPWR VPWR net62 sky130_fd_sc_hd__dfrtp_1
X_1268_ _0386_ _0390_ _0406_ VGND VGND VPWR VPWR _0407_ sky130_fd_sc_hd__o21ai_1
X_1406_ net94 _0544_ VGND VGND VPWR VPWR _0545_ sky130_fd_sc_hd__nor2_1
X_1199_ _0333_ _0336_ VGND VGND VPWR VPWR _0338_ sky130_fd_sc_hd__xnor2_2
XFILLER_35_40 VGND VGND VPWR VPWR sky130_fd_sc_hd__fill_1
XFILLER_19_128 VGND VGND VPWR VPWR sky130_fd_sc_hd__decap_3
XFILLER_42_197 VGND VGND VPWR VPWR sky130_fd_sc_hd__decap_8
XFILLER_35_95 VGND VGND VPWR VPWR sky130_fd_sc_hd__fill_2
XFILLER_35_62 VGND VGND VPWR VPWR sky130_fd_sc_hd__decap_8
X_2171_ _0181_ _0184_ VGND VGND VPWR VPWR _0186_ sky130_fd_sc_hd__xor2_1
X_2240_ _1081_ net84 _0247_ net88 VGND VGND VPWR VPWR _0248_ sky130_fd_sc_hd__a31o_1
XFILLER_33_164 VGND VGND VPWR VPWR sky130_fd_sc_hd__decap_4
X_1955_ _1092_ _1093_ VGND VGND VPWR VPWR _1094_ sky130_fd_sc_hd__nor2_1
X_1886_ _1005_ net193 _1008_ VGND VGND VPWR VPWR _1025_ sky130_fd_sc_hd__o21ai_2
X_2369_ clknet_2_1__leaf_clk _0009_ net135 VGND VGND VPWR VPWR net75 sky130_fd_sc_hd__dfrtp_1
XFILLER_46_83 VGND VGND VPWR VPWR sky130_fd_sc_hd__fill_1
XFILLER_15_142 VGND VGND VPWR VPWR sky130_fd_sc_hd__fill_2
X_1740_ net169 net182 net72 VGND VGND VPWR VPWR _0879_ sky130_fd_sc_hd__a21oi_1
X_1671_ _0807_ _0808_ _0802_ VGND VGND VPWR VPWR _0810_ sky130_fd_sc_hd__a21bo_1
XFILLER_30_3 VGND VGND VPWR VPWR sky130_fd_sc_hd__fill_2
X_2085_ _0097_ _0098_ VGND VGND VPWR VPWR _0100_ sky130_fd_sc_hd__xnor2_1
X_2223_ _1069_ _0235_ VGND VGND VPWR VPWR _0236_ sky130_fd_sc_hd__nor2_1
X_2154_ _0167_ _0168_ VGND VGND VPWR VPWR _0169_ sky130_fd_sc_hd__xnor2_1
X_1869_ _1006_ _1007_ VGND VGND VPWR VPWR _1008_ sky130_fd_sc_hd__or2_1
X_1938_ _1059_ _1073_ _1075_ VGND VGND VPWR VPWR _1077_ sky130_fd_sc_hd__or3_4
XFILLER_29_223 VGND VGND VPWR VPWR sky130_fd_sc_hd__fill_1
XTAP_TAPCELL_ROW_8_149 VGND VPWR sky130_fd_sc_hd__tapvpwrvgnd_1
XFILLER_29_289 VGND VGND VPWR VPWR sky130_fd_sc_hd__decap_3
XFILLER_29_278 VGND VGND VPWR VPWR sky130_fd_sc_hd__fill_2
XFILLER_8_127 VGND VGND VPWR VPWR sky130_fd_sc_hd__fill_2
XFILLER_8_138 VGND VGND VPWR VPWR sky130_fd_sc_hd__fill_2
XFILLER_43_281 VPWR VGND VPWR VGND sky130_ef_sc_hd__decap_12
XFILLER_43_270 VGND VGND VPWR VPWR sky130_fd_sc_hd__decap_8
X_1723_ _0858_ _0859_ _0842_ VGND VGND VPWR VPWR _0862_ sky130_fd_sc_hd__a21oi_1
X_1654_ _0758_ _0761_ _0792_ _0790_ VGND VGND VPWR VPWR _0793_ sky130_fd_sc_hd__a211o_4
X_2206_ _0218_ _0220_ VGND VGND VPWR VPWR _0221_ sky130_fd_sc_hd__xnor2_1
X_1585_ net147 net143 net189 net186 VGND VGND VPWR VPWR _0724_ sky130_fd_sc_hd__and4_1
XFILLER_41_207 VGND VGND VPWR VPWR sky130_fd_sc_hd__fill_1
X_2068_ _1125_ _0082_ VGND VGND VPWR VPWR _0083_ sky130_fd_sc_hd__or2_1
X_2137_ _0538_ _0540_ _0151_ VGND VGND VPWR VPWR _0152_ sky130_fd_sc_hd__o21a_1
XFILLER_27_30 VGND VGND VPWR VPWR sky130_fd_sc_hd__fill_1
XTAP_TAPCELL_ROW_4_130 VGND VPWR sky130_fd_sc_hd__tapvpwrvgnd_1
XFILLER_32_229 VGND VGND VPWR VPWR sky130_fd_sc_hd__fill_1
XTAP_TAPCELL_ROW_27_254 VGND VPWR sky130_fd_sc_hd__tapvpwrvgnd_1
XFILLER_25_292 VGND VGND VPWR VPWR sky130_fd_sc_hd__fill_1
XFILLER_25_281 VGND VGND VPWR VPWR sky130_fd_sc_hd__decap_4
XFILLER_4_141 VGND VGND VPWR VPWR sky130_fd_sc_hd__fill_1
XTAP_TAPCELL_ROW_10_165 VGND VPWR sky130_fd_sc_hd__tapvpwrvgnd_1
X_1370_ net107 _0507_ _0508_ VGND VGND VPWR VPWR _0509_ sky130_fd_sc_hd__nor3_1
X_1706_ _0843_ _0844_ VGND VGND VPWR VPWR _0845_ sky130_fd_sc_hd__nor2_1
X_1637_ _0774_ _0775_ VGND VGND VPWR VPWR _0776_ sky130_fd_sc_hd__nor2_1
XFILLER_48_29 VPWR VGND VPWR VGND sky130_ef_sc_hd__decap_12
X_1499_ net163 net156 net127 net125 VGND VGND VPWR VPWR _0638_ sky130_fd_sc_hd__and4_1
X_1568_ _0664_ _0706_ VGND VGND VPWR VPWR _0707_ sky130_fd_sc_hd__xnor2_1
XTAP_TAPCELL_ROW_1_111 VGND VPWR sky130_fd_sc_hd__tapvpwrvgnd_1
XFILLER_13_43 VGND VGND VPWR VPWR sky130_fd_sc_hd__fill_2
Xfanout88 _0227_ VGND VGND VPWR VPWR net88 sky130_fd_sc_hd__buf_8
Xfanout99 net104 VGND VGND VPWR VPWR net99 sky130_fd_sc_hd__clkbuf_4
XFILLER_22_273 VGND VGND VPWR VPWR sky130_fd_sc_hd__decap_3
XFILLER_1_166 VGND VGND VPWR VPWR sky130_fd_sc_hd__fill_2
XFILLER_8_3 VGND VGND VPWR VPWR sky130_fd_sc_hd__decap_8
XFILLER_9_277 VGND VGND VPWR VPWR sky130_fd_sc_hd__decap_3
X_1422_ _0507_ _0508_ net106 VGND VGND VPWR VPWR _0561_ sky130_fd_sc_hd__o21ai_1
XTAP_TAPCELL_ROW_38_316 VGND VPWR sky130_fd_sc_hd__tapvpwrvgnd_1
X_1353_ _0488_ _0490_ _0476_ _0487_ VGND VGND VPWR VPWR _0492_ sky130_fd_sc_hd__o211a_1
X_1284_ _0412_ _0419_ _0421_ VGND VGND VPWR VPWR _0423_ sky130_fd_sc_hd__nor3_1
XTAP_TAPCELL_ROW_46_360 VGND VPWR sky130_fd_sc_hd__tapvpwrvgnd_1
XFILLER_46_107 VGND VGND VPWR VPWR sky130_fd_sc_hd__fill_1
XFILLER_10_221 VPWR VGND VPWR VGND sky130_ef_sc_hd__decap_12
XFILLER_10_243 VGND VGND VPWR VPWR sky130_fd_sc_hd__decap_8
XFILLER_10_287 VGND VGND VPWR VPWR sky130_fd_sc_hd__fill_2
XFILLER_1_57 VGND VGND VPWR VPWR sky130_fd_sc_hd__decap_4
X_1971_ _1106_ _1107_ net167 net130 VGND VGND VPWR VPWR _1110_ sky130_fd_sc_hd__a2bb2o_1
X_2385_ clknet_2_2__leaf_clk _0025_ net138 VGND VGND VPWR VPWR net61 sky130_fd_sc_hd__dfrtp_1
X_1405_ _0542_ _0543_ VGND VGND VPWR VPWR _0544_ sky130_fd_sc_hd__or2_1
X_1336_ net173 net123 net57 VGND VGND VPWR VPWR _0475_ sky130_fd_sc_hd__a21oi_1
Xinput1 a_in[0] VGND VGND VPWR VPWR net1 sky130_fd_sc_hd__clkbuf_1
X_1267_ net92 _0405_ VGND VGND VPWR VPWR _0406_ sky130_fd_sc_hd__xnor2_1
X_1198_ _0332_ _0336_ VGND VGND VPWR VPWR _0337_ sky130_fd_sc_hd__nor2_1
XFILLER_36_173 VGND VGND VPWR VPWR sky130_fd_sc_hd__decap_3
XFILLER_10_11 VGND VGND VPWR VPWR sky130_fd_sc_hd__decap_8
XPHY_EDGE_ROW_27_Left_77 VGND VGND VPWR VPWR sky130_fd_sc_hd__decap_3
X_2170_ _0181_ _0184_ VGND VGND VPWR VPWR _0185_ sky130_fd_sc_hd__nand2_1
X_1954_ net145 net181 net179 net150 VGND VGND VPWR VPWR _1093_ sky130_fd_sc_hd__a22oi_1
X_1885_ _1018_ _1019_ VGND VGND VPWR VPWR _1024_ sky130_fd_sc_hd__xnor2_1
X_2368_ clknet_2_1__leaf_clk _0008_ net134 VGND VGND VPWR VPWR net74 sky130_fd_sc_hd__dfrtp_1
X_2299_ _0627_ _0291_ VGND VGND VPWR VPWR _0292_ sky130_fd_sc_hd__xor2_1
X_1319_ _0457_ VGND VGND VPWR VPWR _0458_ sky130_fd_sc_hd__inv_2
XFILLER_24_187 VGND VGND VPWR VPWR sky130_fd_sc_hd__decap_8
XFILLER_8_309 VGND VGND VPWR VPWR sky130_fd_sc_hd__decap_4
XFILLER_47_279 VGND VGND VPWR VPWR sky130_fd_sc_hd__fill_1
XFILLER_30_135 VGND VGND VPWR VPWR sky130_fd_sc_hd__decap_4
XFILLER_30_113 VGND VGND VPWR VPWR sky130_fd_sc_hd__decap_4
XFILLER_15_198 VPWR VGND VPWR VGND sky130_ef_sc_hd__decap_12
X_1670_ _0802_ _0807_ _0808_ VGND VGND VPWR VPWR _0809_ sky130_fd_sc_hd__nand3_1
X_2222_ _1064_ _1067_ VGND VGND VPWR VPWR _0235_ sky130_fd_sc_hd__nor2_1
XFILLER_23_3 VGND VGND VPWR VPWR sky130_fd_sc_hd__fill_2
X_2084_ _0097_ _0098_ VGND VGND VPWR VPWR _0099_ sky130_fd_sc_hd__nand2b_1
X_2153_ net96 _0150_ _0149_ VGND VGND VPWR VPWR _0168_ sky130_fd_sc_hd__a21oi_1
X_1937_ _1073_ _1075_ VGND VGND VPWR VPWR _1076_ sky130_fd_sc_hd__nor2_1
XTAP_TAPCELL_ROW_16_193 VGND VPWR sky130_fd_sc_hd__tapvpwrvgnd_1
XFILLER_21_102 VGND VGND VPWR VPWR sky130_fd_sc_hd__fill_1
XFILLER_21_113 VGND VGND VPWR VPWR sky130_fd_sc_hd__decap_3
XFILLER_21_146 VGND VGND VPWR VPWR sky130_fd_sc_hd__fill_1
X_1868_ net148 net191 _0996_ _0998_ VGND VGND VPWR VPWR _1007_ sky130_fd_sc_hd__a211oi_1
X_1799_ _0933_ _0936_ _0937_ VGND VGND VPWR VPWR _0938_ sky130_fd_sc_hd__and3b_1
XFILLER_16_21 VGND VGND VPWR VPWR sky130_fd_sc_hd__fill_1
XFILLER_8_117 VGND VGND VPWR VPWR sky130_fd_sc_hd__fill_2
XFILLER_43_293 VPWR VGND VPWR VGND sky130_ef_sc_hd__decap_12
X_1722_ _0842_ _0858_ _0859_ VGND VGND VPWR VPWR _0861_ sky130_fd_sc_hd__nand3_1
X_1653_ _0788_ _0789_ _0772_ VGND VGND VPWR VPWR _0792_ sky130_fd_sc_hd__a21oi_1
X_1584_ _0716_ _0721_ VGND VGND VPWR VPWR _0723_ sky130_fd_sc_hd__xor2_1
XFILLER_7_183 VGND VGND VPWR VPWR sky130_fd_sc_hd__fill_2
XPHY_EDGE_ROW_9_Right_9 VGND VGND VPWR VPWR sky130_fd_sc_hd__decap_3
X_2205_ net94 _0219_ VGND VGND VPWR VPWR _0220_ sky130_fd_sc_hd__xnor2_1
X_2067_ _1166_ _1167_ VGND VGND VPWR VPWR _0082_ sky130_fd_sc_hd__xor2_1
XFILLER_26_227 VGND VGND VPWR VPWR sky130_fd_sc_hd__fill_2
XPHY_EDGE_ROW_14_Left_64 VGND VGND VPWR VPWR sky130_fd_sc_hd__decap_3
X_2136_ net96 _0150_ VGND VGND VPWR VPWR _0151_ sky130_fd_sc_hd__xor2_1
XTAP_TAPCELL_ROW_4_131 VGND VPWR sky130_fd_sc_hd__tapvpwrvgnd_1
XFILLER_17_249 VGND VGND VPWR VPWR sky130_fd_sc_hd__fill_2
XTAP_TAPCELL_ROW_27_255 VGND VPWR sky130_fd_sc_hd__tapvpwrvgnd_1
XFILLER_25_260 VGND VGND VPWR VPWR sky130_fd_sc_hd__decap_4
XFILLER_4_197 VGND VGND VPWR VPWR sky130_fd_sc_hd__decap_8
X_1705_ net155 net176 net158 net162 VGND VGND VPWR VPWR _0844_ sky130_fd_sc_hd__a22oi_1
XFILLER_31_296 VGND VGND VPWR VPWR sky130_fd_sc_hd__decap_4
XFILLER_31_274 VGND VGND VPWR VPWR sky130_fd_sc_hd__decap_6
XFILLER_31_252 VGND VGND VPWR VPWR sky130_fd_sc_hd__fill_1
X_1636_ net155 net178 net176 net162 VGND VGND VPWR VPWR _0775_ sky130_fd_sc_hd__a22oi_1
X_1567_ _0590_ _0622_ VGND VGND VPWR VPWR _0706_ sky130_fd_sc_hd__xnor2_1
XTAP_TAPCELL_ROW_49_380 VGND VPWR sky130_fd_sc_hd__tapvpwrvgnd_1
X_2119_ _0079_ _0133_ VGND VGND VPWR VPWR _0134_ sky130_fd_sc_hd__nor2_1
X_1498_ net156 net127 net125 net163 VGND VGND VPWR VPWR _0637_ sky130_fd_sc_hd__a22oi_1
XTAP_TAPCELL_ROW_1_112 VGND VPWR sky130_fd_sc_hd__tapvpwrvgnd_1
Xfanout89 _0227_ VGND VGND VPWR VPWR net89 sky130_fd_sc_hd__buf_8
XFILLER_13_66 VGND VGND VPWR VPWR sky130_fd_sc_hd__fill_1
XFILLER_13_88 VGND VGND VPWR VPWR sky130_fd_sc_hd__fill_1
XFILLER_38_63 VGND VGND VPWR VPWR sky130_fd_sc_hd__fill_2
XFILLER_38_85 VGND VGND VPWR VPWR sky130_fd_sc_hd__decap_4
XFILLER_9_223 VGND VGND VPWR VPWR sky130_fd_sc_hd__fill_1
XFILLER_9_256 VGND VGND VPWR VPWR sky130_fd_sc_hd__fill_2
XFILLER_13_241 VPWR VGND VPWR VGND sky130_ef_sc_hd__decap_12
XFILLER_13_274 VGND VGND VPWR VPWR sky130_fd_sc_hd__decap_6
X_1421_ net97 _0513_ VGND VGND VPWR VPWR _0560_ sky130_fd_sc_hd__xnor2_1
XTAP_TAPCELL_ROW_38_317 VGND VPWR sky130_fd_sc_hd__tapvpwrvgnd_1
X_1352_ net107 _0488_ _0489_ VGND VGND VPWR VPWR _0491_ sky130_fd_sc_hd__or3_1
X_1283_ _0419_ _0421_ _0412_ VGND VGND VPWR VPWR _0422_ sky130_fd_sc_hd__o21a_1
XTAP_TAPCELL_ROW_46_361 VGND VPWR sky130_fd_sc_hd__tapvpwrvgnd_1
X_1619_ _0743_ _0756_ _0757_ VGND VGND VPWR VPWR _0758_ sky130_fd_sc_hd__nand3_2
XFILLER_24_98 VGND VGND VPWR VPWR sky130_fd_sc_hd__fill_2
XFILLER_24_43 VGND VGND VPWR VPWR sky130_fd_sc_hd__decap_8
XFILLER_6_248 VGND VGND VPWR VPWR sky130_fd_sc_hd__fill_1
XFILLER_45_152 VGND VGND VPWR VPWR sky130_fd_sc_hd__fill_1
XTAP_TAPCELL_ROW_43_342 VGND VPWR sky130_fd_sc_hd__tapvpwrvgnd_1
X_1970_ _0319_ _1106_ _1107_ net130 VGND VGND VPWR VPWR _1109_ sky130_fd_sc_hd__or4b_1
X_1335_ net173 net123 net57 VGND VGND VPWR VPWR _0474_ sky130_fd_sc_hd__and3_1
XFILLER_5_270 VGND VGND VPWR VPWR sky130_fd_sc_hd__decap_6
X_2384_ clknet_2_2__leaf_clk _0024_ net138 VGND VGND VPWR VPWR net60 sky130_fd_sc_hd__dfrtp_1
X_1404_ _0469_ _0471_ _0541_ VGND VGND VPWR VPWR _0543_ sky130_fd_sc_hd__nor3_1
Xinput2 a_in[10] VGND VGND VPWR VPWR net2 sky130_fd_sc_hd__clkbuf_1
XFILLER_36_185 VGND VGND VPWR VPWR sky130_fd_sc_hd__decap_8
XFILLER_36_141 VGND VGND VPWR VPWR sky130_fd_sc_hd__fill_2
X_1266_ _0403_ _0404_ VGND VGND VPWR VPWR _0405_ sky130_fd_sc_hd__nand2_1
X_1197_ net141 _0326_ _0335_ VGND VGND VPWR VPWR _0336_ sky130_fd_sc_hd__a21oi_2
XFILLER_3_229 VGND VGND VPWR VPWR sky130_fd_sc_hd__decap_3
XFILLER_10_23 VGND VGND VPWR VPWR sky130_fd_sc_hd__decap_4
XFILLER_19_32 VGND VGND VPWR VPWR sky130_fd_sc_hd__decap_3
XFILLER_19_54 VGND VGND VPWR VPWR sky130_fd_sc_hd__fill_2
XFILLER_19_87 VGND VGND VPWR VPWR sky130_fd_sc_hd__fill_2
XFILLER_42_166 VGND VGND VPWR VPWR sky130_fd_sc_hd__fill_1
XFILLER_27_163 VGND VGND VPWR VPWR sky130_fd_sc_hd__decap_4
XPHY_EDGE_ROW_2_Left_52 VGND VGND VPWR VPWR sky130_fd_sc_hd__decap_3
XFILLER_2_251 VGND VGND VPWR VPWR sky130_fd_sc_hd__fill_1
XFILLER_18_152 VGND VGND VPWR VPWR sky130_fd_sc_hd__decap_4
X_1953_ net150 net145 net181 net179 VGND VGND VPWR VPWR _1092_ sky130_fd_sc_hd__and4_1
XFILLER_33_177 VGND VGND VPWR VPWR sky130_fd_sc_hd__fill_1
X_1884_ _0984_ _0986_ VGND VGND VPWR VPWR _1023_ sky130_fd_sc_hd__xnor2_2
X_2298_ _0708_ _0284_ _0711_ VGND VGND VPWR VPWR _0291_ sky130_fd_sc_hd__a21bo_1
X_2367_ clknet_2_0__leaf_clk _0007_ net134 VGND VGND VPWR VPWR net73 sky130_fd_sc_hd__dfrtp_2
X_1318_ _0455_ _0456_ VGND VGND VPWR VPWR _0457_ sky130_fd_sc_hd__and2_1
XFILLER_24_122 VGND VGND VPWR VPWR sky130_fd_sc_hd__fill_2
X_1249_ _0371_ _0382_ _0385_ VGND VGND VPWR VPWR _0388_ sky130_fd_sc_hd__nor3_1
XFILLER_12_306 VGND VGND VPWR VPWR sky130_fd_sc_hd__fill_2
XPHY_EDGE_ROW_44_Left_94 VGND VGND VPWR VPWR sky130_fd_sc_hd__decap_3
XFILLER_47_225 VPWR VGND VPWR VGND sky130_ef_sc_hd__decap_12
XFILLER_46_85 VGND VGND VPWR VPWR sky130_fd_sc_hd__decap_6
XFILLER_15_111 VGND VGND VPWR VPWR sky130_fd_sc_hd__fill_1
XFILLER_15_122 VPWR VGND VPWR VGND sky130_ef_sc_hd__decap_12
XFILLER_7_57 VGND VGND VPWR VPWR sky130_fd_sc_hd__fill_2
XFILLER_7_46 VGND VGND VPWR VPWR sky130_fd_sc_hd__fill_2
XFILLER_38_236 VGND VGND VPWR VPWR sky130_fd_sc_hd__decap_8
X_2221_ net278 net110 net98 _0234_ VGND VGND VPWR VPWR _0001_ sky130_fd_sc_hd__a22o_1
X_2152_ net96 _0444_ VGND VGND VPWR VPWR _0167_ sky130_fd_sc_hd__xnor2_1
X_2083_ _0688_ _0690_ VGND VGND VPWR VPWR _0098_ sky130_fd_sc_hd__xnor2_1
XFILLER_38_258 VGND VGND VPWR VPWR sky130_fd_sc_hd__decap_8
X_1867_ _0996_ _0998_ net148 net191 VGND VGND VPWR VPWR _1006_ sky130_fd_sc_hd__o211a_1
X_1936_ _1014_ _1072_ _1043_ VGND VGND VPWR VPWR _1075_ sky130_fd_sc_hd__a21oi_1
XTAP_TAPCELL_ROW_16_194 VGND VPWR sky130_fd_sc_hd__tapvpwrvgnd_1
XFILLER_21_169 VGND VGND VPWR VPWR sky130_fd_sc_hd__decap_6
X_1798_ _0825_ _0934_ _0926_ _0924_ VGND VGND VPWR VPWR _0937_ sky130_fd_sc_hd__o211ai_2
XFILLER_16_55 VGND VGND VPWR VPWR sky130_fd_sc_hd__fill_2
XFILLER_20_191 VGND VGND VPWR VPWR sky130_fd_sc_hd__decap_4
X_1721_ _0842_ _0858_ _0859_ VGND VGND VPWR VPWR _0860_ sky130_fd_sc_hd__and3_1
XFILLER_7_140 VGND VGND VPWR VPWR sky130_fd_sc_hd__decap_8
X_1652_ _0772_ _0788_ net206 VGND VGND VPWR VPWR _0791_ sky130_fd_sc_hd__nand3_1
X_1583_ _0716_ _0721_ VGND VGND VPWR VPWR _0722_ sky130_fd_sc_hd__and2_1
XFILLER_26_217 VGND VGND VPWR VPWR sky130_fd_sc_hd__decap_4
X_2204_ _0391_ _0393_ VGND VGND VPWR VPWR _0219_ sky130_fd_sc_hd__or2_1
X_2135_ _0147_ _0148_ VGND VGND VPWR VPWR _0150_ sky130_fd_sc_hd__xnor2_1
X_2066_ _1168_ _0080_ VGND VGND VPWR VPWR _0081_ sky130_fd_sc_hd__xor2_1
X_1919_ _1046_ _1057_ VGND VGND VPWR VPWR _1058_ sky130_fd_sc_hd__nor2_1
XFILLER_49_309 VGND VGND VPWR VPWR sky130_fd_sc_hd__decap_8
XTAP_TAPCELL_ROW_4_132 VGND VPWR sky130_fd_sc_hd__tapvpwrvgnd_1
XFILLER_1_305 VPWR VGND VPWR VGND sky130_ef_sc_hd__decap_12
XFILLER_32_209 VGND VGND VPWR VPWR sky130_fd_sc_hd__decap_8
XTAP_TAPCELL_ROW_27_256 VGND VPWR sky130_fd_sc_hd__tapvpwrvgnd_1
XFILLER_43_86 VGND VGND VPWR VPWR sky130_fd_sc_hd__decap_3
XFILLER_4_154 VGND VGND VPWR VPWR sky130_fd_sc_hd__fill_2
XFILLER_4_121 VGND VGND VPWR VPWR sky130_fd_sc_hd__decap_3
XFILLER_4_58 VGND VGND VPWR VPWR sky130_fd_sc_hd__fill_1
XPHY_EDGE_ROW_31_Left_81 VGND VGND VPWR VPWR sky130_fd_sc_hd__decap_3
XFILLER_31_242 VGND VGND VPWR VPWR sky130_fd_sc_hd__decap_4
XFILLER_31_231 VGND VGND VPWR VPWR sky130_fd_sc_hd__decap_6
XFILLER_16_261 VGND VGND VPWR VPWR sky130_fd_sc_hd__decap_3
XFILLER_16_272 VGND VGND VPWR VPWR sky130_fd_sc_hd__fill_1
X_1704_ net162 net155 net176 net158 VGND VGND VPWR VPWR _0843_ sky130_fd_sc_hd__and4_1
X_1497_ _0633_ _0635_ _0597_ _0632_ VGND VGND VPWR VPWR _0636_ sky130_fd_sc_hd__o211ai_2
X_1635_ net162 net155 net178 net176 VGND VGND VPWR VPWR _0774_ sky130_fd_sc_hd__and4_1
X_1566_ _0704_ VGND VGND VPWR VPWR _0705_ sky130_fd_sc_hd__inv_2
XTAP_TAPCELL_ROW_49_381 VGND VPWR sky130_fd_sc_hd__tapvpwrvgnd_1
X_2118_ _0126_ _0127_ VGND VGND VPWR VPWR _0133_ sky130_fd_sc_hd__xnor2_1
X_2049_ _0672_ _0062_ _0063_ VGND VGND VPWR VPWR _0064_ sky130_fd_sc_hd__nand3_1
XTAP_TAPCELL_ROW_1_113 VGND VPWR sky130_fd_sc_hd__tapvpwrvgnd_1
XTAP_TAPCELL_ROW_32_281 VGND VPWR sky130_fd_sc_hd__tapvpwrvgnd_1
XFILLER_22_253 VGND VGND VPWR VPWR sky130_fd_sc_hd__fill_2
XTAP_TAPCELL_ROW_24_237 VGND VPWR sky130_fd_sc_hd__tapvpwrvgnd_1
XFILLER_1_113 VGND VGND VPWR VPWR sky130_fd_sc_hd__fill_1
XFILLER_13_253 VGND VGND VPWR VPWR sky130_fd_sc_hd__decap_4
X_1351_ net107 _0488_ _0489_ VGND VGND VPWR VPWR _0490_ sky130_fd_sc_hd__nor3_1
X_1420_ _0525_ net205 VGND VGND VPWR VPWR _0559_ sky130_fd_sc_hd__xnor2_1
XFILLER_48_194 VGND VGND VPWR VPWR sky130_fd_sc_hd__fill_2
XTAP_TAPCELL_ROW_38_318 VGND VPWR sky130_fd_sc_hd__tapvpwrvgnd_1
XFILLER_36_301 VGND VGND VPWR VPWR sky130_fd_sc_hd__decap_6
X_1282_ net95 _0420_ VGND VGND VPWR VPWR _0421_ sky130_fd_sc_hd__and2_1
XTAP_TAPCELL_ROW_46_362 VGND VPWR sky130_fd_sc_hd__tapvpwrvgnd_1
X_1618_ _0754_ _0755_ _0748_ VGND VGND VPWR VPWR _0757_ sky130_fd_sc_hd__a21o_1
X_1549_ net142 _0323_ VGND VGND VPWR VPWR _0688_ sky130_fd_sc_hd__nand2_1
XFILLER_39_150 VGND VGND VPWR VPWR sky130_fd_sc_hd__fill_1
XFILLER_24_66 VGND VGND VPWR VPWR sky130_fd_sc_hd__decap_4
XFILLER_49_41 VPWR VGND VPWR VGND sky130_ef_sc_hd__decap_12
XFILLER_40_98 VGND VGND VPWR VPWR sky130_fd_sc_hd__decap_3
XFILLER_49_85 VGND VGND VPWR VPWR sky130_fd_sc_hd__decap_6
XFILLER_1_15 VPWR VGND VPWR VGND sky130_ef_sc_hd__decap_12
XTAP_TAPCELL_ROW_43_343 VGND VPWR sky130_fd_sc_hd__tapvpwrvgnd_1
X_1334_ net106 _0467_ VGND VGND VPWR VPWR _0473_ sky130_fd_sc_hd__xnor2_1
X_2383_ clknet_2_3__leaf_clk _0023_ net139 VGND VGND VPWR VPWR net59 sky130_fd_sc_hd__dfrtp_1
X_1265_ _0367_ _0370_ _0402_ VGND VGND VPWR VPWR _0404_ sky130_fd_sc_hd__or3_1
XPHY_EDGE_ROW_18_Right_18 VGND VGND VPWR VPWR sky130_fd_sc_hd__decap_3
X_1403_ _0469_ _0471_ _0541_ VGND VGND VPWR VPWR _0542_ sky130_fd_sc_hd__o21a_1
Xinput3 a_in[11] VGND VGND VPWR VPWR net3 sky130_fd_sc_hd__buf_1
XFILLER_36_197 VGND VGND VPWR VPWR sky130_fd_sc_hd__decap_8
XPHY_EDGE_ROW_27_Right_27 VGND VGND VPWR VPWR sky130_fd_sc_hd__decap_3
X_1196_ _0328_ _0334_ VGND VGND VPWR VPWR _0335_ sky130_fd_sc_hd__nor2_1
XPHY_EDGE_ROW_36_Right_36 VGND VGND VPWR VPWR sky130_fd_sc_hd__decap_3
XFILLER_10_35 VGND VGND VPWR VPWR sky130_fd_sc_hd__fill_1
XFILLER_27_142 VGND VGND VPWR VPWR sky130_fd_sc_hd__fill_1
XPHY_EDGE_ROW_45_Right_45 VGND VGND VPWR VPWR sky130_fd_sc_hd__decap_3
XFILLER_42_101 VPWR VGND VPWR VGND sky130_ef_sc_hd__decap_12
XFILLER_30_307 VGND VGND VPWR VPWR sky130_fd_sc_hd__fill_1
XFILLER_18_131 VGND VGND VPWR VPWR sky130_fd_sc_hd__fill_2
XFILLER_18_197 VGND VGND VPWR VPWR sky130_fd_sc_hd__decap_3
X_1952_ net183 net142 VGND VGND VPWR VPWR _1091_ sky130_fd_sc_hd__nand2b_1
X_1883_ _0984_ _1021_ _0987_ VGND VGND VPWR VPWR _1022_ sky130_fd_sc_hd__a21oi_1
X_2297_ net270 net115 net103 _0290_ VGND VGND VPWR VPWR _0021_ sky130_fd_sc_hd__a22o_1
X_2366_ clknet_2_0__leaf_clk _0006_ net134 VGND VGND VPWR VPWR net72 sky130_fd_sc_hd__dfrtp_1
X_1317_ _0433_ _0454_ VGND VGND VPWR VPWR _0456_ sky130_fd_sc_hd__or2_1
X_1248_ _0328_ _0338_ _0337_ VGND VGND VPWR VPWR _0387_ sky130_fd_sc_hd__a21o_1
XFILLER_21_78 VGND VGND VPWR VPWR sky130_fd_sc_hd__fill_1
XFILLER_21_89 VGND VGND VPWR VPWR sky130_fd_sc_hd__fill_1
XFILLER_47_237 VPWR VGND VPWR VGND sky130_ef_sc_hd__decap_12
XFILLER_46_97 VGND VGND VPWR VPWR sky130_fd_sc_hd__fill_2
XFILLER_15_101 VGND VGND VPWR VPWR sky130_fd_sc_hd__decap_3
XFILLER_15_134 VGND VGND VPWR VPWR sky130_fd_sc_hd__decap_8
XFILLER_7_36 VGND VGND VPWR VPWR sky130_fd_sc_hd__fill_1
XFILLER_15_167 VGND VGND VPWR VPWR sky130_fd_sc_hd__fill_1
X_2082_ _0057_ _0060_ _0058_ VGND VGND VPWR VPWR _0097_ sky130_fd_sc_hd__o21ba_1
X_2220_ _1068_ net84 _0233_ net88 VGND VGND VPWR VPWR _0234_ sky130_fd_sc_hd__a31o_1
X_2151_ _0340_ _0448_ VGND VGND VPWR VPWR _0166_ sky130_fd_sc_hd__xnor2_1
X_1866_ _0967_ net218 _1002_ VGND VGND VPWR VPWR _1005_ sky130_fd_sc_hd__a21oi_2
X_1935_ _1014_ _1043_ _1072_ VGND VGND VPWR VPWR _1074_ sky130_fd_sc_hd__nand3_1
XTAP_TAPCELL_ROW_16_195 VGND VPWR sky130_fd_sc_hd__tapvpwrvgnd_1
X_1797_ _0924_ _0926_ _0934_ _0825_ VGND VGND VPWR VPWR _0936_ sky130_fd_sc_hd__a211o_1
XFILLER_21_159 VGND VGND VPWR VPWR sky130_fd_sc_hd__decap_3
X_2349_ net250 net115 net103 net5 VGND VGND VPWR VPWR _0045_ sky130_fd_sc_hd__a22o_1
XFILLER_37_281 VGND VGND VPWR VPWR sky130_fd_sc_hd__decap_8
XPHY_EDGE_ROW_0_Right_0 VGND VGND VPWR VPWR sky130_fd_sc_hd__decap_3
X_1720_ _0855_ _0856_ _0857_ VGND VGND VPWR VPWR _0859_ sky130_fd_sc_hd__a21o_1
X_1651_ _0772_ _0789_ _0788_ VGND VGND VPWR VPWR _0790_ sky130_fd_sc_hd__and3_1
X_1582_ _0717_ _0720_ VGND VGND VPWR VPWR _0721_ sky130_fd_sc_hd__xnor2_1
X_2065_ _0077_ _0078_ VGND VGND VPWR VPWR _0080_ sky130_fd_sc_hd__xor2_1
X_2203_ _0396_ _0395_ net95 VGND VGND VPWR VPWR _0218_ sky130_fd_sc_hd__mux2_1
X_2134_ _0148_ _0147_ VGND VGND VPWR VPWR _0149_ sky130_fd_sc_hd__and2b_1
XFILLER_19_281 VGND VGND VPWR VPWR sky130_fd_sc_hd__fill_1
XFILLER_34_251 VGND VGND VPWR VPWR sky130_fd_sc_hd__fill_1
X_1918_ _1053_ _1056_ _1047_ VGND VGND VPWR VPWR _1057_ sky130_fd_sc_hd__o21ai_1
X_1849_ _0982_ _0983_ VGND VGND VPWR VPWR _0988_ sky130_fd_sc_hd__xor2_1
XFILLER_1_317 VGND VGND VPWR VPWR sky130_fd_sc_hd__decap_3
XTAP_TAPCELL_ROW_27_257 VGND VPWR sky130_fd_sc_hd__tapvpwrvgnd_1
XFILLER_27_55 VGND VGND VPWR VPWR sky130_fd_sc_hd__fill_1
XFILLER_25_251 VGND VGND VPWR VPWR sky130_fd_sc_hd__fill_2
XFILLER_17_207 VGND VGND VPWR VPWR sky130_fd_sc_hd__decap_8
XFILLER_40_221 VGND VGND VPWR VPWR sky130_fd_sc_hd__decap_3
XFILLER_4_37 VGND VGND VPWR VPWR sky130_fd_sc_hd__fill_1
XFILLER_4_15 VPWR VGND VPWR VGND sky130_ef_sc_hd__decap_12
X_1703_ _0839_ _0840_ VGND VGND VPWR VPWR _0842_ sky130_fd_sc_hd__xnor2_1
X_1634_ _0755_ _0748_ _0754_ VGND VGND VPWR VPWR _0773_ sky130_fd_sc_hd__a21bo_1
X_1496_ net108 _0633_ _0634_ VGND VGND VPWR VPWR _0635_ sky130_fd_sc_hd__nor3_2
X_1565_ _0702_ _0703_ VGND VGND VPWR VPWR _0704_ sky130_fd_sc_hd__or2_1
XTAP_TAPCELL_ROW_49_382 VGND VPWR sky130_fd_sc_hd__tapvpwrvgnd_1
X_2117_ _0130_ _0131_ VGND VGND VPWR VPWR _0132_ sky130_fd_sc_hd__nand2_1
X_2048_ _1148_ _1150_ _1149_ VGND VGND VPWR VPWR _0063_ sky130_fd_sc_hd__o21bai_1
XTAP_TAPCELL_ROW_1_114 VGND VPWR sky130_fd_sc_hd__tapvpwrvgnd_1
XTAP_TAPCELL_ROW_32_282 VGND VPWR sky130_fd_sc_hd__tapvpwrvgnd_1
XTAP_TAPCELL_ROW_24_238 VGND VPWR sky130_fd_sc_hd__tapvpwrvgnd_1
XFILLER_9_269 VGND VGND VPWR VPWR sky130_fd_sc_hd__decap_8
X_1350_ net173 net123 net56 VGND VGND VPWR VPWR _0489_ sky130_fd_sc_hd__a21oi_1
X_1281_ _0414_ _0418_ VGND VGND VPWR VPWR _0420_ sky130_fd_sc_hd__xor2_1
XTAP_TAPCELL_ROW_46_363 VGND VPWR sky130_fd_sc_hd__tapvpwrvgnd_1
XTAP_TAPCELL_ROW_38_319 VGND VPWR sky130_fd_sc_hd__tapvpwrvgnd_1
X_1617_ _0748_ _0754_ net204 VGND VGND VPWR VPWR _0756_ sky130_fd_sc_hd__nand3_1
X_1548_ net149 net144 net158 net133 VGND VGND VPWR VPWR _0687_ sky130_fd_sc_hd__and4_1
X_1479_ _0604_ _0617_ _0583_ _0591_ VGND VGND VPWR VPWR _0618_ sky130_fd_sc_hd__o211a_1
XFILLER_24_23 VGND VGND VPWR VPWR sky130_fd_sc_hd__fill_2
XFILLER_40_33 VGND VGND VPWR VPWR sky130_fd_sc_hd__fill_1
XFILLER_6_239 VGND VGND VPWR VPWR sky130_fd_sc_hd__fill_2
XFILLER_10_257 VGND VGND VPWR VPWR sky130_fd_sc_hd__fill_1
XFILLER_49_53 VGND VGND VPWR VPWR sky130_fd_sc_hd__decap_3
XFILLER_6_3 VPWR VGND VPWR VGND sky130_ef_sc_hd__decap_12
XFILLER_1_27 VPWR VGND VPWR VGND sky130_ef_sc_hd__decap_12
XTAP_TAPCELL_ROW_43_344 VGND VPWR sky130_fd_sc_hd__tapvpwrvgnd_1
X_1402_ net96 _0539_ VGND VGND VPWR VPWR _0541_ sky130_fd_sc_hd__xor2_1
Xinput4 a_in[12] VGND VGND VPWR VPWR net4 sky130_fd_sc_hd__buf_1
X_2382_ clknet_2_3__leaf_clk _0022_ net139 VGND VGND VPWR VPWR net58 sky130_fd_sc_hd__dfrtp_1
X_1333_ net97 _0470_ VGND VGND VPWR VPWR _0472_ sky130_fd_sc_hd__xor2_1
X_1264_ _0367_ _0370_ _0402_ VGND VGND VPWR VPWR _0403_ sky130_fd_sc_hd__o21ai_1
XFILLER_36_165 VGND VGND VPWR VPWR sky130_fd_sc_hd__decap_8
Xclkbuf_2_1__f_clk clknet_0_clk VGND VGND VPWR VPWR clknet_2_1__leaf_clk sky130_fd_sc_hd__clkbuf_16
X_1195_ net148 net143 net121 VGND VGND VPWR VPWR _0334_ sky130_fd_sc_hd__o21ai_1
XFILLER_10_58 VGND VGND VPWR VPWR sky130_fd_sc_hd__decap_4
XFILLER_42_179 VPWR VGND VPWR VGND sky130_ef_sc_hd__decap_12
XFILLER_42_113 VGND VGND VPWR VPWR sky130_fd_sc_hd__decap_6
XTAP_TAPCELL_ROW_40_325 VGND VPWR sky130_fd_sc_hd__tapvpwrvgnd_1
XFILLER_35_55 VGND VGND VPWR VPWR sky130_fd_sc_hd__fill_1
XFILLER_2_253 VPWR VGND VPWR VGND sky130_ef_sc_hd__decap_12
X_1951_ _0844_ _0846_ _0843_ VGND VGND VPWR VPWR _1090_ sky130_fd_sc_hd__o21ba_1
X_1882_ _0988_ _1020_ VGND VGND VPWR VPWR _1021_ sky130_fd_sc_hd__or2_1
X_2365_ clknet_2_0__leaf_clk _0005_ net134 VGND VGND VPWR VPWR net71 sky130_fd_sc_hd__dfrtp_2
X_2296_ net87 _0288_ _0289_ net91 VGND VGND VPWR VPWR _0290_ sky130_fd_sc_hd__a31o_1
X_1247_ _0382_ _0385_ _0371_ VGND VGND VPWR VPWR _0386_ sky130_fd_sc_hd__o21a_1
X_1316_ _0433_ _0454_ VGND VGND VPWR VPWR _0455_ sky130_fd_sc_hd__nand2_1
XFILLER_21_13 VGND VGND VPWR VPWR sky130_fd_sc_hd__fill_1
XFILLER_47_216 VGND VGND VPWR VPWR sky130_fd_sc_hd__decap_8
XFILLER_47_249 VPWR VGND VPWR VGND sky130_ef_sc_hd__decap_12
XFILLER_46_76 VGND VGND VPWR VPWR sky130_fd_sc_hd__fill_1
XFILLER_15_113 VGND VGND VPWR VPWR sky130_fd_sc_hd__decap_3
XFILLER_7_15 VPWR VGND VPWR VGND sky130_ef_sc_hd__decap_12
X_2081_ _0680_ _0094_ _0095_ VGND VGND VPWR VPWR _0096_ sky130_fd_sc_hd__nand3_2
XFILLER_38_216 VGND VGND VPWR VPWR sky130_fd_sc_hd__decap_6
XFILLER_38_205 VGND VGND VPWR VPWR sky130_fd_sc_hd__fill_2
X_2150_ _0164_ VGND VGND VPWR VPWR _0165_ sky130_fd_sc_hd__inv_2
XFILLER_46_271 VPWR VGND VPWR VGND sky130_ef_sc_hd__decap_12
X_1934_ _1014_ _1043_ _1072_ VGND VGND VPWR VPWR _1073_ sky130_fd_sc_hd__and3_1
XTAP_TAPCELL_ROW_16_196 VGND VPWR sky130_fd_sc_hd__tapvpwrvgnd_1
XFILLER_21_138 VGND VGND VPWR VPWR sky130_fd_sc_hd__fill_2
X_1865_ _0967_ _1003_ _1002_ VGND VGND VPWR VPWR _1004_ sky130_fd_sc_hd__and3_1
X_1796_ _0924_ _0926_ _0934_ _0825_ VGND VGND VPWR VPWR _0935_ sky130_fd_sc_hd__a211oi_1
X_2348_ net254 net112 net100 net131 VGND VGND VPWR VPWR _0044_ sky130_fd_sc_hd__a22o_1
X_2279_ net86 _0276_ net90 VGND VGND VPWR VPWR _0277_ sky130_fd_sc_hd__a21o_1
XFILLER_16_13 VGND VGND VPWR VPWR sky130_fd_sc_hd__decap_8
XFILLER_12_127 VGND VGND VPWR VPWR sky130_fd_sc_hd__fill_1
XFILLER_28_293 VGND VGND VPWR VPWR sky130_fd_sc_hd__fill_1
X_1650_ _0786_ _0787_ _0773_ VGND VGND VPWR VPWR _0789_ sky130_fd_sc_hd__a21o_1
XTAP_TAPCELL_ROW_13_177 VGND VPWR sky130_fd_sc_hd__tapvpwrvgnd_1
X_1581_ _0718_ _0719_ VGND VGND VPWR VPWR _0720_ sky130_fd_sc_hd__nor2_1
X_2202_ _0340_ _0400_ _0399_ VGND VGND VPWR VPWR _0217_ sky130_fd_sc_hd__a21oi_1
XFILLER_21_3 VGND VGND VPWR VPWR sky130_fd_sc_hd__fill_2
X_2064_ _0077_ _0078_ VGND VGND VPWR VPWR _0079_ sky130_fd_sc_hd__nand2b_1
X_2133_ net105 _0534_ _0533_ VGND VGND VPWR VPWR _0148_ sky130_fd_sc_hd__o21ba_1
X_1917_ net161 net190 _1055_ VGND VGND VPWR VPWR _1056_ sky130_fd_sc_hd__and3_1
X_1779_ _0915_ _0916_ VGND VGND VPWR VPWR _0918_ sky130_fd_sc_hd__xnor2_1
X_1848_ _0986_ VGND VGND VPWR VPWR _0987_ sky130_fd_sc_hd__inv_2
XFILLER_27_45 VGND VGND VPWR VPWR sky130_fd_sc_hd__decap_3
XFILLER_43_55 VGND VGND VPWR VPWR sky130_fd_sc_hd__fill_1
XTAP_TAPCELL_ROW_27_258 VGND VPWR sky130_fd_sc_hd__tapvpwrvgnd_1
XFILLER_25_241 VGND VGND VPWR VPWR sky130_fd_sc_hd__decap_3
XFILLER_40_277 VGND VGND VPWR VPWR sky130_fd_sc_hd__fill_1
XFILLER_4_27 VGND VGND VPWR VPWR sky130_fd_sc_hd__fill_1
XFILLER_31_222 VGND VGND VPWR VPWR sky130_fd_sc_hd__fill_2
XFILLER_16_285 VGND VGND VPWR VPWR sky130_fd_sc_hd__fill_1
X_1564_ _0665_ _0701_ VGND VGND VPWR VPWR _0703_ sky130_fd_sc_hd__nor2_1
X_1702_ _0840_ _0839_ VGND VGND VPWR VPWR _0841_ sky130_fd_sc_hd__and2b_1
X_1633_ _0769_ _0770_ VGND VGND VPWR VPWR _0772_ sky130_fd_sc_hd__xnor2_1
XPHY_EDGE_ROW_18_Left_68 VGND VGND VPWR VPWR sky130_fd_sc_hd__decap_3
X_1495_ net174 net125 net51 VGND VGND VPWR VPWR _0634_ sky130_fd_sc_hd__a21oi_1
XTAP_TAPCELL_ROW_1_115 VGND VPWR sky130_fd_sc_hd__tapvpwrvgnd_1
XTAP_TAPCELL_ROW_49_383 VGND VPWR sky130_fd_sc_hd__tapvpwrvgnd_1
X_2116_ _0119_ _0129_ _0128_ VGND VGND VPWR VPWR _0131_ sky130_fd_sc_hd__o21ai_1
X_2047_ net167 net128 _0670_ _0671_ VGND VGND VPWR VPWR _0062_ sky130_fd_sc_hd__a22o_1
XTAP_TAPCELL_ROW_24_239 VGND VPWR sky130_fd_sc_hd__tapvpwrvgnd_1
XFILLER_22_222 VGND VGND VPWR VPWR sky130_fd_sc_hd__fill_2
XTAP_TAPCELL_ROW_32_283 VGND VPWR sky130_fd_sc_hd__tapvpwrvgnd_1
XFILLER_22_244 VGND VGND VPWR VPWR sky130_fd_sc_hd__decap_4
XFILLER_38_55 VGND VGND VPWR VPWR sky130_fd_sc_hd__decap_8
XFILLER_9_215 VGND VGND VPWR VPWR sky130_fd_sc_hd__fill_2
XFILLER_13_222 VGND VGND VPWR VPWR sky130_fd_sc_hd__fill_2
X_1280_ _0414_ _0418_ VGND VGND VPWR VPWR _0419_ sky130_fd_sc_hd__and2_1
X_1547_ _0683_ _0684_ VGND VGND VPWR VPWR _0686_ sky130_fd_sc_hd__xnor2_1
X_1616_ _0753_ _0752_ net198 _0736_ VGND VGND VPWR VPWR _0755_ sky130_fd_sc_hd__a211o_1
X_1478_ _0615_ _0616_ VGND VGND VPWR VPWR _0617_ sky130_fd_sc_hd__nor2_1
XFILLER_42_317 VGND VGND VPWR VPWR sky130_fd_sc_hd__decap_3
XFILLER_42_306 VGND VGND VPWR VPWR sky130_fd_sc_hd__fill_2
XFILLER_24_57 VGND VGND VPWR VPWR sky130_fd_sc_hd__decap_3
XFILLER_10_236 VGND VGND VPWR VPWR sky130_fd_sc_hd__fill_2
XTAP_TAPCELL_ROW_20_220 VGND VPWR sky130_fd_sc_hd__tapvpwrvgnd_1
XFILLER_45_111 VGND VGND VPWR VPWR sky130_fd_sc_hd__fill_1
XFILLER_1_39 VPWR VGND VPWR VGND sky130_ef_sc_hd__decap_12
XTAP_TAPCELL_ROW_43_345 VGND VPWR sky130_fd_sc_hd__tapvpwrvgnd_1
X_2381_ clknet_2_3__leaf_clk _0021_ net139 VGND VGND VPWR VPWR net57 sky130_fd_sc_hd__dfrtp_1
XFILLER_5_295 VGND VGND VPWR VPWR sky130_fd_sc_hd__fill_1
X_1401_ net95 _0539_ VGND VGND VPWR VPWR _0540_ sky130_fd_sc_hd__and2_1
Xinput5 a_in[13] VGND VGND VPWR VPWR net5 sky130_fd_sc_hd__dlymetal6s2s_1
X_1194_ net152 _0331_ _0329_ VGND VGND VPWR VPWR _0333_ sky130_fd_sc_hd__a21o_1
X_1332_ net97 _0470_ VGND VGND VPWR VPWR _0471_ sky130_fd_sc_hd__and2_1
X_1263_ net94 _0401_ VGND VGND VPWR VPWR _0402_ sky130_fd_sc_hd__xnor2_1
XFILLER_24_306 VGND VGND VPWR VPWR sky130_fd_sc_hd__fill_2
XFILLER_19_46 VGND VGND VPWR VPWR sky130_fd_sc_hd__fill_2
XFILLER_27_155 VGND VGND VPWR VPWR sky130_fd_sc_hd__fill_1
XFILLER_19_57 VGND VGND VPWR VPWR sky130_fd_sc_hd__fill_1
XFILLER_42_147 VGND VGND VPWR VPWR sky130_fd_sc_hd__fill_1
XTAP_TAPCELL_ROW_40_326 VGND VPWR sky130_fd_sc_hd__tapvpwrvgnd_1
XFILLER_30_309 VGND VGND VPWR VPWR sky130_fd_sc_hd__decap_3
XFILLER_2_265 VPWR VGND VPWR VGND sky130_ef_sc_hd__decap_12
XFILLER_33_169 VGND VGND VPWR VPWR sky130_fd_sc_hd__decap_8
XFILLER_33_103 VGND VGND VPWR VPWR sky130_fd_sc_hd__fill_2
X_1950_ _1088_ _0872_ VGND VGND VPWR VPWR _1089_ sky130_fd_sc_hd__and2b_1
X_1881_ _1018_ _1019_ _1017_ VGND VGND VPWR VPWR _1020_ sky130_fd_sc_hd__a21oi_1
X_2364_ clknet_2_0__leaf_clk _0004_ net134 VGND VGND VPWR VPWR net70 sky130_fd_sc_hd__dfrtp_1
X_1315_ _0453_ _0434_ VGND VGND VPWR VPWR _0454_ sky130_fd_sc_hd__and2b_1
X_2295_ _0707_ _0287_ VGND VGND VPWR VPWR _0289_ sky130_fd_sc_hd__or2_1
X_1246_ net94 _0384_ VGND VGND VPWR VPWR _0385_ sky130_fd_sc_hd__nor2_1
XPHY_EDGE_ROW_6_Left_56 VGND VGND VPWR VPWR sky130_fd_sc_hd__decap_3
XFILLER_15_169 VGND VGND VPWR VPWR sky130_fd_sc_hd__decap_4
XFILLER_30_139 VGND VGND VPWR VPWR sky130_fd_sc_hd__fill_1
XFILLER_7_27 VGND VGND VPWR VPWR sky130_fd_sc_hd__fill_2
XFILLER_46_283 VPWR VGND VPWR VGND sky130_ef_sc_hd__decap_12
XFILLER_46_250 VGND VGND VPWR VPWR sky130_fd_sc_hd__fill_2
X_2080_ _0061_ _0065_ _0064_ VGND VGND VPWR VPWR _0095_ sky130_fd_sc_hd__a21bo_1
XFILLER_16_6 VGND VGND VPWR VPWR sky130_fd_sc_hd__fill_1
X_1933_ _1012_ _1013_ _1006_ VGND VGND VPWR VPWR _1072_ sky130_fd_sc_hd__a21o_1
XTAP_TAPCELL_ROW_16_197 VGND VPWR sky130_fd_sc_hd__tapvpwrvgnd_1
XFILLER_21_106 VGND VGND VPWR VPWR sky130_fd_sc_hd__decap_6
X_1864_ _0960_ _0961_ _0966_ VGND VGND VPWR VPWR _1003_ sky130_fd_sc_hd__a21o_1
X_1795_ _0812_ _0824_ _0823_ VGND VGND VPWR VPWR _0934_ sky130_fd_sc_hd__o21a_1
X_2347_ net248 net112 net100 net133 VGND VGND VPWR VPWR _0043_ sky130_fd_sc_hd__a22o_1
XPHY_EDGE_ROW_48_Left_98 VGND VGND VPWR VPWR sky130_fd_sc_hd__decap_3
X_2278_ _0132_ _0275_ VGND VGND VPWR VPWR _0276_ sky130_fd_sc_hd__xnor2_1
XFILLER_29_239 VGND VGND VPWR VPWR sky130_fd_sc_hd__fill_2
XFILLER_37_272 VGND VGND VPWR VPWR sky130_fd_sc_hd__fill_2
X_1229_ _0357_ _0364_ _0366_ VGND VGND VPWR VPWR _0368_ sky130_fd_sc_hd__nor3_1
XFILLER_16_36 VGND VGND VPWR VPWR sky130_fd_sc_hd__decap_4
XFILLER_16_47 VGND VGND VPWR VPWR sky130_fd_sc_hd__decap_8
XFILLER_32_13 VGND VGND VPWR VPWR sky130_fd_sc_hd__decap_3
XFILLER_4_305 VGND VGND VPWR VPWR sky130_fd_sc_hd__decap_3
XFILLER_7_110 VGND VGND VPWR VPWR sky130_fd_sc_hd__fill_2
XTAP_TAPCELL_ROW_13_178 VGND VPWR sky130_fd_sc_hd__tapvpwrvgnd_1
X_1580_ net145 net186 net185 net147 VGND VGND VPWR VPWR _0719_ sky130_fd_sc_hd__a22oi_1
X_2132_ net105 _0441_ VGND VGND VPWR VPWR _0147_ sky130_fd_sc_hd__xnor2_1
X_2201_ _0214_ _0215_ VGND VGND VPWR VPWR _0216_ sky130_fd_sc_hd__nand2_1
X_2063_ _1131_ _1163_ _1162_ VGND VGND VPWR VPWR _0078_ sky130_fd_sc_hd__a21bo_1
XFILLER_34_253 VGND VGND VPWR VPWR sky130_fd_sc_hd__decap_3
XFILLER_34_297 VGND VGND VPWR VPWR sky130_fd_sc_hd__decap_3
X_1916_ _1053_ _1054_ VGND VGND VPWR VPWR _1055_ sky130_fd_sc_hd__nor2_1
X_1847_ _0941_ _0985_ VGND VGND VPWR VPWR _0986_ sky130_fd_sc_hd__nor2_1
X_1778_ _0915_ _0916_ VGND VGND VPWR VPWR _0917_ sky130_fd_sc_hd__and2b_1
XFILLER_27_57 VGND VGND VPWR VPWR sky130_fd_sc_hd__decap_6
XFILLER_43_78 VGND VGND VPWR VPWR sky130_fd_sc_hd__decap_8
XFILLER_43_23 VGND VGND VPWR VPWR sky130_fd_sc_hd__decap_3
XFILLER_40_256 VPWR VGND VPWR VGND sky130_ef_sc_hd__decap_12
XFILLER_40_234 VGND VGND VPWR VPWR sky130_fd_sc_hd__fill_1
XFILLER_48_301 VGND VGND VPWR VPWR sky130_fd_sc_hd__decap_6
XFILLER_16_231 VGND VGND VPWR VPWR sky130_fd_sc_hd__fill_1
XFILLER_16_253 VGND VGND VPWR VPWR sky130_fd_sc_hd__decap_8
XTAP_TAPCELL_ROW_18_204 VGND VPWR sky130_fd_sc_hd__tapvpwrvgnd_1
X_1701_ _0763_ _0765_ _0764_ VGND VGND VPWR VPWR _0840_ sky130_fd_sc_hd__o21ba_1
X_1494_ net174 net125 net51 VGND VGND VPWR VPWR _0633_ sky130_fd_sc_hd__and3_1
X_1563_ _0665_ _0701_ VGND VGND VPWR VPWR _0702_ sky130_fd_sc_hd__and2_1
X_1632_ _0770_ _0769_ VGND VGND VPWR VPWR _0771_ sky130_fd_sc_hd__nand2b_1
XTAP_TAPCELL_ROW_49_384 VGND VPWR sky130_fd_sc_hd__tapvpwrvgnd_1
X_2115_ _0119_ _0128_ _0129_ VGND VGND VPWR VPWR _0130_ sky130_fd_sc_hd__or3_1
X_2046_ _0059_ _0060_ VGND VGND VPWR VPWR _0061_ sky130_fd_sc_hd__xnor2_1
XFILLER_13_15 VGND VGND VPWR VPWR sky130_fd_sc_hd__decap_8
XTAP_TAPCELL_ROW_32_284 VGND VPWR sky130_fd_sc_hd__tapvpwrvgnd_1
XFILLER_38_89 VGND VGND VPWR VPWR sky130_fd_sc_hd__fill_1
XPHY_EDGE_ROW_35_Left_85 VGND VGND VPWR VPWR sky130_fd_sc_hd__decap_3
XFILLER_9_238 VGND VGND VPWR VPWR sky130_fd_sc_hd__fill_1
XFILLER_36_315 VGND VGND VPWR VPWR sky130_fd_sc_hd__fill_1
XFILLER_0_160 VGND VGND VPWR VPWR sky130_fd_sc_hd__fill_1
XFILLER_0_193 VGND VGND VPWR VPWR sky130_fd_sc_hd__decap_3
XFILLER_48_197 VPWR VGND VPWR VGND sky130_ef_sc_hd__decap_12
X_1546_ _0683_ _0684_ VGND VGND VPWR VPWR _0685_ sky130_fd_sc_hd__nand2b_1
X_1477_ _0592_ _0603_ VGND VGND VPWR VPWR _0616_ sky130_fd_sc_hd__xor2_1
X_1615_ net198 _0736_ net217 _0753_ VGND VGND VPWR VPWR _0754_ sky130_fd_sc_hd__o211ai_2
XTAP_TAPCELL_ROW_37_310 VGND VPWR sky130_fd_sc_hd__tapvpwrvgnd_1
X_2029_ _1166_ _1167_ VGND VGND VPWR VPWR _1168_ sky130_fd_sc_hd__nand2b_1
XFILLER_10_215 VGND VGND VPWR VPWR sky130_fd_sc_hd__fill_1
XFILLER_18_315 VGND VGND VPWR VPWR sky130_fd_sc_hd__fill_1
XTAP_TAPCELL_ROW_43_346 VGND VPWR sky130_fd_sc_hd__tapvpwrvgnd_1
XFILLER_46_6 VPWR VGND VPWR VGND sky130_ef_sc_hd__decap_12
X_2380_ clknet_2_3__leaf_clk _0020_ net139 VGND VGND VPWR VPWR net56 sky130_fd_sc_hd__dfrtp_1
X_1331_ _0464_ _0468_ VGND VGND VPWR VPWR _0470_ sky130_fd_sc_hd__xnor2_1
XFILLER_5_263 VGND VGND VPWR VPWR sky130_fd_sc_hd__fill_1
X_1400_ _0536_ _0537_ VGND VGND VPWR VPWR _0539_ sky130_fd_sc_hd__xnor2_1
Xinput6 a_in[14] VGND VGND VPWR VPWR net6 sky130_fd_sc_hd__clkbuf_1
X_1193_ net152 _0331_ _0329_ VGND VGND VPWR VPWR _0332_ sky130_fd_sc_hd__a21oi_2
X_1262_ _0399_ _0400_ VGND VGND VPWR VPWR _0401_ sky130_fd_sc_hd__and2b_1
XFILLER_10_27 VGND VGND VPWR VPWR sky130_fd_sc_hd__fill_1
X_1529_ _0636_ _0642_ _0641_ VGND VGND VPWR VPWR _0668_ sky130_fd_sc_hd__a21o_1
XFILLER_27_178 VPWR VGND VPWR VGND sky130_ef_sc_hd__decap_12
XFILLER_27_167 VGND VGND VPWR VPWR sky130_fd_sc_hd__fill_1
XTAP_TAPCELL_ROW_40_327 VGND VPWR sky130_fd_sc_hd__tapvpwrvgnd_1
XPHY_EDGE_ROW_14_Right_14 VGND VGND VPWR VPWR sky130_fd_sc_hd__decap_3
XFILLER_2_277 VPWR VGND VPWR VGND sky130_ef_sc_hd__decap_12
XPHY_EDGE_ROW_23_Right_23 VGND VGND VPWR VPWR sky130_fd_sc_hd__decap_3
XFILLER_18_101 VGND VGND VPWR VPWR sky130_fd_sc_hd__decap_6
XFILLER_18_156 VGND VGND VPWR VPWR sky130_fd_sc_hd__fill_1
XPHY_EDGE_ROW_32_Right_32 VGND VGND VPWR VPWR sky130_fd_sc_hd__decap_3
X_1880_ _1015_ _1016_ VGND VGND VPWR VPWR _1019_ sky130_fd_sc_hd__xnor2_1
XFILLER_18_178 VGND VGND VPWR VPWR sky130_fd_sc_hd__decap_3
XPHY_EDGE_ROW_41_Right_41 VGND VGND VPWR VPWR sky130_fd_sc_hd__decap_3
X_2294_ _0707_ _0287_ VGND VGND VPWR VPWR _0288_ sky130_fd_sc_hd__nand2_1
XFILLER_2_61 VGND VGND VPWR VPWR sky130_fd_sc_hd__fill_2
X_2363_ clknet_2_0__leaf_clk _0003_ net134 VGND VGND VPWR VPWR net69 sky130_fd_sc_hd__dfrtp_1
X_1314_ net93 _0452_ _0450_ VGND VGND VPWR VPWR _0453_ sky130_fd_sc_hd__a21oi_1
XPHY_EDGE_ROW_22_Left_72 VGND VGND VPWR VPWR sky130_fd_sc_hd__decap_3
XFILLER_49_281 VPWR VGND VPWR VGND sky130_ef_sc_hd__decap_12
XFILLER_2_83 VGND VGND VPWR VPWR sky130_fd_sc_hd__fill_1
X_1245_ _0382_ _0383_ VGND VGND VPWR VPWR _0384_ sky130_fd_sc_hd__or2_1
XFILLER_32_181 VPWR VGND VPWR VGND sky130_ef_sc_hd__decap_12
XFILLER_47_207 VGND VGND VPWR VPWR sky130_fd_sc_hd__fill_1
XFILLER_7_303 VPWR VGND VPWR VGND sky130_ef_sc_hd__decap_12
XFILLER_46_295 VPWR VGND VPWR VGND sky130_ef_sc_hd__decap_12
XFILLER_38_229 VGND VGND VPWR VPWR sky130_fd_sc_hd__fill_2
Xinput20 b_in[3] VGND VGND VPWR VPWR net20 sky130_fd_sc_hd__clkbuf_1
X_1863_ _0995_ _1000_ _0994_ VGND VGND VPWR VPWR _1002_ sky130_fd_sc_hd__a21bo_1
X_1932_ _1046_ _1070_ _1060_ VGND VGND VPWR VPWR _1071_ sky130_fd_sc_hd__or3_4
XTAP_TAPCELL_ROW_16_198 VGND VPWR sky130_fd_sc_hd__tapvpwrvgnd_1
X_2415_ clknet_2_0__leaf_clk _0055_ net135 VGND VGND VPWR VPWR net83 sky130_fd_sc_hd__dfrtp_1
X_1794_ _0917_ _0920_ VGND VGND VPWR VPWR _0933_ sky130_fd_sc_hd__nor2_1
X_2346_ net257 net112 net100 net159 VGND VGND VPWR VPWR _0042_ sky130_fd_sc_hd__a22o_1
X_2277_ _0134_ _0272_ VGND VGND VPWR VPWR _0275_ sky130_fd_sc_hd__nand2b_1
X_1228_ _0364_ _0366_ _0357_ VGND VGND VPWR VPWR _0367_ sky130_fd_sc_hd__o21a_1
XFILLER_37_262 VGND VGND VPWR VPWR sky130_fd_sc_hd__fill_1
XFILLER_4_317 VGND VGND VPWR VPWR sky130_fd_sc_hd__decap_3
XFILLER_20_173 VGND VGND VPWR VPWR sky130_fd_sc_hd__decap_8
XFILLER_20_195 VGND VGND VPWR VPWR sky130_fd_sc_hd__fill_1
XTAP_TAPCELL_ROW_7_144 VGND VPWR sky130_fd_sc_hd__tapvpwrvgnd_1
XFILLER_43_232 VPWR VGND VPWR VGND sky130_ef_sc_hd__decap_12
XFILLER_11_151 VGND VGND VPWR VPWR sky130_fd_sc_hd__fill_2
XTAP_TAPCELL_ROW_13_179 VGND VPWR sky130_fd_sc_hd__tapvpwrvgnd_1
XFILLER_11_195 VGND VGND VPWR VPWR sky130_fd_sc_hd__decap_3
X_2062_ _1169_ _0076_ VGND VGND VPWR VPWR _0077_ sky130_fd_sc_hd__xnor2_1
X_2200_ _0431_ _0455_ _0213_ VGND VGND VPWR VPWR _0215_ sky130_fd_sc_hd__nand3_1
X_2131_ _0143_ _0144_ _0556_ VGND VGND VPWR VPWR _0146_ sky130_fd_sc_hd__a21o_1
XFILLER_34_221 VPWR VGND VPWR VGND sky130_ef_sc_hd__decap_12
X_1915_ _1031_ _1048_ _1049_ _1051_ VGND VGND VPWR VPWR _1054_ sky130_fd_sc_hd__a211oi_1
X_1777_ _0818_ _0820_ VGND VGND VPWR VPWR _0916_ sky130_fd_sc_hd__xnor2_1
X_1846_ _0939_ _0940_ _0932_ VGND VGND VPWR VPWR _0985_ sky130_fd_sc_hd__a21oi_1
XPHY_EDGE_ROW_4_Right_4 VGND VGND VPWR VPWR sky130_fd_sc_hd__decap_3
XFILLER_25_232 VGND VGND VPWR VPWR sky130_fd_sc_hd__decap_3
X_2329_ net85 _0314_ net89 VGND VGND VPWR VPWR _0315_ sky130_fd_sc_hd__a21o_1
XFILLER_43_57 VGND VGND VPWR VPWR sky130_fd_sc_hd__decap_6
XFILLER_40_268 VGND VGND VPWR VPWR sky130_fd_sc_hd__fill_2
XFILLER_40_246 VGND VGND VPWR VPWR sky130_fd_sc_hd__fill_1
Xclone34 net175 VGND VGND VPWR VPWR net225 sky130_fd_sc_hd__buf_6
XFILLER_4_29 VGND VGND VPWR VPWR sky130_fd_sc_hd__decap_8
XTAP_TAPCELL_ROW_18_205 VGND VPWR sky130_fd_sc_hd__tapvpwrvgnd_1
X_1700_ _0832_ _0837_ VGND VGND VPWR VPWR _0839_ sky130_fd_sc_hd__xnor2_1
XFILLER_31_246 VGND VGND VPWR VPWR sky130_fd_sc_hd__fill_1
X_1631_ _0717_ _0719_ _0718_ VGND VGND VPWR VPWR _0770_ sky130_fd_sc_hd__o21ba_1
X_1493_ _0594_ _0595_ net108 VGND VGND VPWR VPWR _0632_ sky130_fd_sc_hd__o21ai_1
X_1562_ _0666_ _0700_ VGND VGND VPWR VPWR _0701_ sky130_fd_sc_hd__nor2_1
XTAP_TAPCELL_ROW_49_385 VGND VPWR sky130_fd_sc_hd__tapvpwrvgnd_1
X_2114_ _0109_ _0113_ _0115_ _0118_ VGND VGND VPWR VPWR _0129_ sky130_fd_sc_hd__o211a_1
X_2045_ net153 net133 VGND VGND VPWR VPWR _0060_ sky130_fd_sc_hd__nand2_1
XTAP_TAPCELL_ROW_32_285 VGND VPWR sky130_fd_sc_hd__tapvpwrvgnd_1
X_1829_ _0961_ _0966_ _0960_ VGND VGND VPWR VPWR _0968_ sky130_fd_sc_hd__a21bo_1
XFILLER_45_305 VPWR VGND VPWR VGND sky130_ef_sc_hd__decap_12
XFILLER_0_150 VGND VGND VPWR VPWR sky130_fd_sc_hd__fill_2
X_1614_ _0749_ _0750_ net166 net176 VGND VGND VPWR VPWR _0753_ sky130_fd_sc_hd__a2bb2o_1
XFILLER_8_250 VGND VGND VPWR VPWR sky130_fd_sc_hd__fill_2
XFILLER_8_283 VGND VGND VPWR VPWR sky130_fd_sc_hd__decap_6
XFILLER_39_121 VGND VGND VPWR VPWR sky130_fd_sc_hd__fill_2
X_1545_ _0651_ _0653_ VGND VGND VPWR VPWR _0684_ sky130_fd_sc_hd__xnor2_1
X_1476_ _0613_ _0614_ VGND VGND VPWR VPWR _0615_ sky130_fd_sc_hd__nand2_1
XTAP_TAPCELL_ROW_37_311 VGND VPWR sky130_fd_sc_hd__tapvpwrvgnd_1
X_2028_ _1121_ _1123_ VGND VGND VPWR VPWR _1167_ sky130_fd_sc_hd__nand2_1
XFILLER_40_47 VGND VGND VPWR VPWR sky130_fd_sc_hd__decap_8
XFILLER_45_113 VGND VGND VPWR VPWR sky130_fd_sc_hd__fill_2
XFILLER_45_179 VGND VGND VPWR VPWR sky130_fd_sc_hd__decap_6
XFILLER_5_253 VGND VGND VPWR VPWR sky130_fd_sc_hd__fill_1
X_1330_ _0468_ _0464_ VGND VGND VPWR VPWR _0469_ sky130_fd_sc_hd__and2b_1
X_1261_ _0354_ _0356_ _0398_ VGND VGND VPWR VPWR _0400_ sky130_fd_sc_hd__or3b_1
XFILLER_36_135 VGND VGND VPWR VPWR sky130_fd_sc_hd__decap_4
X_1192_ _0329_ _0330_ VGND VGND VPWR VPWR _0331_ sky130_fd_sc_hd__nor2_2
Xinput7 a_in[15] VGND VGND VPWR VPWR net7 sky130_fd_sc_hd__clkbuf_1
X_1459_ _0594_ _0596_ _0565_ _0593_ VGND VGND VPWR VPWR _0598_ sky130_fd_sc_hd__o211ai_2
X_1528_ _0645_ _0657_ _0656_ VGND VGND VPWR VPWR _0667_ sky130_fd_sc_hd__a21o_1
XFILLER_42_138 VGND VGND VPWR VPWR sky130_fd_sc_hd__fill_2
XTAP_TAPCELL_ROW_40_328 VGND VPWR sky130_fd_sc_hd__tapvpwrvgnd_1
XFILLER_4_3 VPWR VGND VPWR VGND sky130_ef_sc_hd__decap_12
XFILLER_2_289 VPWR VGND VPWR VGND sky130_ef_sc_hd__decap_12
XFILLER_49_293 VPWR VGND VPWR VGND sky130_ef_sc_hd__decap_12
XFILLER_49_271 VGND VGND VPWR VPWR sky130_fd_sc_hd__decap_8
XFILLER_37_3 VGND VGND VPWR VPWR sky130_fd_sc_hd__decap_4
X_2293_ _0705_ _0284_ _0702_ VGND VGND VPWR VPWR _0287_ sky130_fd_sc_hd__a21oi_1
X_2362_ clknet_2_0__leaf_clk _0002_ net134 VGND VGND VPWR VPWR net66 sky130_fd_sc_hd__dfrtp_1
X_1244_ _0372_ _0379_ _0381_ VGND VGND VPWR VPWR _0383_ sky130_fd_sc_hd__nor3_1
X_1313_ _0450_ _0451_ VGND VGND VPWR VPWR _0452_ sky130_fd_sc_hd__nor2_1
XFILLER_17_190 VGND VGND VPWR VPWR sky130_fd_sc_hd__decap_8
XFILLER_32_193 VGND VGND VPWR VPWR sky130_fd_sc_hd__decap_3
XFILLER_7_315 VGND VGND VPWR VPWR sky130_fd_sc_hd__decap_4
Xinput21 b_in[4] VGND VGND VPWR VPWR net21 sky130_fd_sc_hd__buf_2
X_1862_ _0994_ _0995_ _1000_ VGND VGND VPWR VPWR _1001_ sky130_fd_sc_hd__nand3_1
X_1931_ _1062_ _1069_ VGND VGND VPWR VPWR _1070_ sky130_fd_sc_hd__nand2_1
Xinput10 a_in[3] VGND VGND VPWR VPWR net10 sky130_fd_sc_hd__clkbuf_1
X_1793_ _0929_ _0930_ _0928_ VGND VGND VPWR VPWR _0932_ sky130_fd_sc_hd__a21o_1
X_2414_ clknet_2_2__leaf_clk _0054_ net137 VGND VGND VPWR VPWR net82 sky130_fd_sc_hd__dfrtp_1
X_2345_ net262 net112 net100 net177 VGND VGND VPWR VPWR _0041_ sky130_fd_sc_hd__a22o_1
X_2276_ net51 net115 net103 _0274_ VGND VGND VPWR VPWR _0016_ sky130_fd_sc_hd__a22o_1
X_1227_ net95 _0365_ VGND VGND VPWR VPWR _0366_ sky130_fd_sc_hd__and2_1
XFILLER_32_26 VGND VGND VPWR VPWR sky130_fd_sc_hd__fill_2
XTAP_TAPCELL_ROW_7_145 VGND VPWR sky130_fd_sc_hd__tapvpwrvgnd_1
XFILLER_43_244 VPWR VGND VPWR VGND sky130_ef_sc_hd__decap_12
X_2061_ _0074_ _0075_ VGND VGND VPWR VPWR _0076_ sky130_fd_sc_hd__nor2_1
X_2130_ _0143_ _0144_ _0556_ VGND VGND VPWR VPWR _0145_ sky130_fd_sc_hd__a21oi_1
XFILLER_34_233 VGND VGND VPWR VPWR sky130_fd_sc_hd__decap_6
X_1914_ _1049_ _1051_ _1031_ _1048_ VGND VGND VPWR VPWR _1053_ sky130_fd_sc_hd__o211a_1
XFILLER_8_83 VGND VGND VPWR VPWR sky130_fd_sc_hd__fill_1
X_1776_ _0891_ _0893_ VGND VGND VPWR VPWR _0915_ sky130_fd_sc_hd__nor2_1
X_1845_ _0983_ _0982_ VGND VGND VPWR VPWR _0984_ sky130_fd_sc_hd__nand2b_1
X_2328_ _0210_ _0313_ VGND VGND VPWR VPWR _0314_ sky130_fd_sc_hd__xor2_1
X_2259_ net86 _0261_ net90 VGND VGND VPWR VPWR _0262_ sky130_fd_sc_hd__a21o_1
XFILLER_43_47 VGND VGND VPWR VPWR sky130_fd_sc_hd__decap_8
XTAP_TAPCELL_ROW_18_206 VGND VPWR sky130_fd_sc_hd__tapvpwrvgnd_1
XTAP_TAPCELL_ROW_26_250 VGND VPWR sky130_fd_sc_hd__tapvpwrvgnd_1
XFILLER_16_277 VGND VGND VPWR VPWR sky130_fd_sc_hd__decap_8
XFILLER_17_92 VPWR VGND VPWR VGND sky130_ef_sc_hd__decap_12
X_1630_ _0762_ _0767_ VGND VGND VPWR VPWR _0769_ sky130_fd_sc_hd__xor2_1
X_1561_ _0697_ _0698_ _0696_ VGND VGND VPWR VPWR _0700_ sky130_fd_sc_hd__o21ba_1
XFILLER_39_303 VPWR VGND VPWR VGND sky130_ef_sc_hd__decap_12
X_1492_ _0598_ _0601_ _0600_ VGND VGND VPWR VPWR _0631_ sky130_fd_sc_hd__a21o_1
XTAP_TAPCELL_ROW_49_375 VGND VPWR sky130_fd_sc_hd__tapvpwrvgnd_1
X_2044_ _0057_ _0058_ VGND VGND VPWR VPWR _0059_ sky130_fd_sc_hd__nor2_1
X_2113_ _0126_ _0127_ VGND VGND VPWR VPWR _0128_ sky130_fd_sc_hd__or2_1
XTAP_TAPCELL_ROW_32_286 VGND VPWR sky130_fd_sc_hd__tapvpwrvgnd_1
X_1828_ _0960_ net192 _0966_ VGND VGND VPWR VPWR _0967_ sky130_fd_sc_hd__nand3_1
X_1759_ _0896_ _0897_ VGND VGND VPWR VPWR _0898_ sky130_fd_sc_hd__nand2_1
XFILLER_45_317 VGND VGND VPWR VPWR sky130_fd_sc_hd__decap_3
XFILLER_13_225 VGND VGND VPWR VPWR sky130_fd_sc_hd__decap_4
X_1544_ _0674_ _0677_ _0675_ VGND VGND VPWR VPWR _0683_ sky130_fd_sc_hd__o21ba_1
X_1613_ _0319_ _0323_ _0749_ _0750_ VGND VGND VPWR VPWR _0752_ sky130_fd_sc_hd__or4_4
XFILLER_5_51 VGND VGND VPWR VPWR sky130_fd_sc_hd__decap_4
XFILLER_12_291 VGND VGND VPWR VPWR sky130_fd_sc_hd__decap_3
XFILLER_39_144 VGND VGND VPWR VPWR sky130_fd_sc_hd__decap_6
XFILLER_39_100 VPWR VGND VPWR VGND sky130_ef_sc_hd__decap_12
X_1475_ _0607_ _0612_ VGND VGND VPWR VPWR _0614_ sky130_fd_sc_hd__nand2b_1
XFILLER_42_309 VGND VGND VPWR VPWR sky130_fd_sc_hd__decap_8
X_2027_ _1164_ _1165_ VGND VGND VPWR VPWR _1166_ sky130_fd_sc_hd__or2_1
XTAP_TAPCELL_ROW_37_312 VGND VPWR sky130_fd_sc_hd__tapvpwrvgnd_1
XFILLER_40_26 VGND VGND VPWR VPWR sky130_fd_sc_hd__fill_2
XFILLER_49_57 VPWR VGND VPWR VGND sky130_ef_sc_hd__decap_12
XFILLER_45_136 VGND VGND VPWR VPWR sky130_fd_sc_hd__decap_3
XFILLER_5_243 VGND VGND VPWR VPWR sky130_fd_sc_hd__fill_1
X_1191_ net163 net156 net125 VGND VGND VPWR VPWR _0330_ sky130_fd_sc_hd__o21ai_1
Xinput8 a_in[1] VGND VGND VPWR VPWR net8 sky130_fd_sc_hd__buf_1
X_1260_ _0354_ _0356_ _0398_ VGND VGND VPWR VPWR _0399_ sky130_fd_sc_hd__o21ba_1
X_1527_ _0661_ _0662_ VGND VGND VPWR VPWR _0666_ sky130_fd_sc_hd__xnor2_1
XFILLER_10_29 VGND VGND VPWR VPWR sky130_fd_sc_hd__decap_6
X_1458_ net108 _0594_ _0595_ VGND VGND VPWR VPWR _0597_ sky130_fd_sc_hd__or3_1
X_1389_ _0515_ _0527_ _0504_ VGND VGND VPWR VPWR _0528_ sky130_fd_sc_hd__o21ai_1
XFILLER_27_136 VGND VGND VPWR VPWR sky130_fd_sc_hd__decap_6
XFILLER_19_38 VGND VGND VPWR VPWR sky130_fd_sc_hd__decap_8
XFILLER_42_128 VGND VGND VPWR VPWR sky130_fd_sc_hd__decap_6
XTAP_TAPCELL_ROW_40_329 VGND VPWR sky130_fd_sc_hd__tapvpwrvgnd_1
XFILLER_27_169 VGND VGND VPWR VPWR sky130_fd_sc_hd__fill_2
XFILLER_33_139 VPWR VGND VPWR VGND sky130_ef_sc_hd__decap_12
XFILLER_25_70 VGND VGND VPWR VPWR sky130_fd_sc_hd__decap_6
X_2361_ clknet_2_0__leaf_clk _0001_ net137 VGND VGND VPWR VPWR net55 sky130_fd_sc_hd__dfrtp_1
X_2292_ net269 net115 net103 _0286_ VGND VGND VPWR VPWR _0020_ sky130_fd_sc_hd__a22o_1
XFILLER_2_41 VPWR VGND VPWR VGND sky130_ef_sc_hd__decap_12
X_1243_ _0379_ _0381_ _0372_ VGND VGND VPWR VPWR _0382_ sky130_fd_sc_hd__o21a_1
X_1312_ _0435_ _0446_ _0449_ VGND VGND VPWR VPWR _0451_ sky130_fd_sc_hd__nor3_1
XFILLER_24_139 VGND VGND VPWR VPWR sky130_fd_sc_hd__fill_1
XFILLER_46_58 VPWR VGND VPWR VGND sky130_ef_sc_hd__decap_12
XFILLER_23_194 VGND VGND VPWR VPWR sky130_fd_sc_hd__decap_3
XFILLER_11_61 VGND VGND VPWR VPWR sky130_fd_sc_hd__decap_8
XFILLER_46_253 VGND VGND VPWR VPWR sky130_fd_sc_hd__decap_3
X_1930_ _1064_ _1067_ VGND VGND VPWR VPWR _1069_ sky130_fd_sc_hd__and2_1
Xinput22 b_in[5] VGND VGND VPWR VPWR net22 sky130_fd_sc_hd__clkbuf_2
X_1861_ _0998_ _0999_ VGND VGND VPWR VPWR _1000_ sky130_fd_sc_hd__nor2_1
Xinput11 a_in[4] VGND VGND VPWR VPWR net11 sky130_fd_sc_hd__clkbuf_1
X_1792_ _0928_ _0930_ VGND VGND VPWR VPWR _0931_ sky130_fd_sc_hd__and2b_1
X_2344_ net256 net116 net104 net178 VGND VGND VPWR VPWR _0040_ sky130_fd_sc_hd__a22o_1
X_2413_ clknet_2_0__leaf_clk _0053_ net137 VGND VGND VPWR VPWR net81 sky130_fd_sc_hd__dfrtp_1
X_2275_ net86 _0272_ _0273_ net90 VGND VGND VPWR VPWR _0274_ sky130_fd_sc_hd__a31o_1
X_1226_ _0359_ _0363_ VGND VGND VPWR VPWR _0365_ sky130_fd_sc_hd__xor2_1
XFILLER_20_197 VGND VGND VPWR VPWR sky130_fd_sc_hd__decap_3
XTAP_TAPCELL_ROW_7_146 VGND VPWR sky130_fd_sc_hd__tapvpwrvgnd_1
XFILLER_43_278 VGND VGND VPWR VPWR sky130_fd_sc_hd__fill_2
XFILLER_43_256 VGND VGND VPWR VPWR sky130_fd_sc_hd__fill_1
XFILLER_7_113 VGND VGND VPWR VPWR sky130_fd_sc_hd__decap_8
XFILLER_11_175 VGND VGND VPWR VPWR sky130_fd_sc_hd__fill_2
X_2060_ _0071_ _0073_ _1158_ _1160_ VGND VGND VPWR VPWR _0075_ sky130_fd_sc_hd__o211a_1
XFILLER_34_267 VPWR VGND VPWR VGND sky130_ef_sc_hd__decap_12
X_1913_ _0319_ _1049_ _1050_ net190 VGND VGND VPWR VPWR _1052_ sky130_fd_sc_hd__or4b_1
X_1775_ _0902_ _0913_ VGND VGND VPWR VPWR _0914_ sky130_fd_sc_hd__nor2_1
X_1844_ _0929_ _0931_ VGND VGND VPWR VPWR _0983_ sky130_fd_sc_hd__xnor2_1
X_2258_ _1089_ _0260_ VGND VGND VPWR VPWR _0261_ sky130_fd_sc_hd__nor2_1
XTAP_TAPCELL_ROW_4_127 VGND VPWR sky130_fd_sc_hd__tapvpwrvgnd_1
X_2327_ _0197_ _0205_ _0203_ VGND VGND VPWR VPWR _0313_ sky130_fd_sc_hd__o21ba_1
XFILLER_43_15 VGND VGND VPWR VPWR sky130_fd_sc_hd__decap_8
XFILLER_25_278 VGND VGND VPWR VPWR sky130_fd_sc_hd__fill_2
XFILLER_25_223 VGND VGND VPWR VPWR sky130_fd_sc_hd__fill_1
X_1209_ net105 _0345_ _0346_ VGND VGND VPWR VPWR _0348_ sky130_fd_sc_hd__nor3_1
X_2189_ _0180_ _0202_ VGND VGND VPWR VPWR _0204_ sky130_fd_sc_hd__nor2_1
XTAP_TAPCELL_ROW_18_207 VGND VPWR sky130_fd_sc_hd__tapvpwrvgnd_1
XFILLER_31_237 VGND VGND VPWR VPWR sky130_fd_sc_hd__fill_1
XTAP_TAPCELL_ROW_26_251 VGND VPWR sky130_fd_sc_hd__tapvpwrvgnd_1
X_1560_ _0696_ _0698_ VGND VGND VPWR VPWR _0699_ sky130_fd_sc_hd__nor2_1
X_2112_ _1169_ _0076_ _0074_ VGND VGND VPWR VPWR _0127_ sky130_fd_sc_hd__a21oi_2
XFILLER_39_315 VGND VGND VPWR VPWR sky130_fd_sc_hd__fill_1
X_1491_ _0615_ _0616_ VGND VGND VPWR VPWR _0630_ sky130_fd_sc_hd__xnor2_1
XFILLER_12_3 VGND VGND VPWR VPWR sky130_fd_sc_hd__fill_2
XTAP_TAPCELL_ROW_49_376 VGND VPWR sky130_fd_sc_hd__tapvpwrvgnd_1
X_2043_ net163 net157 net131 net5 VGND VGND VPWR VPWR _0058_ sky130_fd_sc_hd__and4_1
X_1827_ _0962_ _0965_ VGND VGND VPWR VPWR _0966_ sky130_fd_sc_hd__xnor2_1
X_1758_ _0877_ _0879_ _0878_ VGND VGND VPWR VPWR _0897_ sky130_fd_sc_hd__o21bai_1
X_1689_ _0761_ _0826_ _0825_ _0812_ VGND VGND VPWR VPWR _0828_ sky130_fd_sc_hd__a211oi_1
XFILLER_38_37 VPWR VGND VPWR VGND sky130_ef_sc_hd__decap_12
XTAP_TAPCELL_ROW_23_232 VGND VPWR sky130_fd_sc_hd__tapvpwrvgnd_1
XFILLER_21_281 VGND VGND VPWR VPWR sky130_fd_sc_hd__fill_1
XFILLER_0_141 VGND VGND VPWR VPWR sky130_fd_sc_hd__fill_2
XFILLER_36_307 VGND VGND VPWR VPWR sky130_fd_sc_hd__fill_1
XFILLER_8_263 VGND VGND VPWR VPWR sky130_fd_sc_hd__decap_6
X_1543_ _0643_ _0668_ _0681_ VGND VGND VPWR VPWR _0682_ sky130_fd_sc_hd__and3_1
X_1474_ _0612_ _0607_ VGND VGND VPWR VPWR _0613_ sky130_fd_sc_hd__nand2b_1
X_1612_ _0749_ _0750_ net166 net176 VGND VGND VPWR VPWR _0751_ sky130_fd_sc_hd__and4bb_1
XFILLER_5_96 VGND VGND VPWR VPWR sky130_fd_sc_hd__fill_1
XFILLER_39_189 VPWR VGND VPWR VGND sky130_ef_sc_hd__decap_12
XFILLER_39_167 VGND VGND VPWR VPWR sky130_fd_sc_hd__fill_1
XTAP_TAPCELL_ROW_37_313 VGND VPWR sky130_fd_sc_hd__tapvpwrvgnd_1
X_2026_ _1162_ _1163_ _1131_ VGND VGND VPWR VPWR _1165_ sky130_fd_sc_hd__a21oi_1
XFILLER_49_69 VPWR VGND VPWR VGND sky130_ef_sc_hd__decap_12
XPHY_EDGE_ROW_39_Left_89 VGND VGND VPWR VPWR sky130_fd_sc_hd__decap_3
XFILLER_14_83 VGND VGND VPWR VPWR sky130_fd_sc_hd__fill_1
X_1190_ net163 net156 net125 VGND VGND VPWR VPWR _0329_ sky130_fd_sc_hd__and3_1
Xinput9 a_in[2] VGND VGND VPWR VPWR net9 sky130_fd_sc_hd__buf_1
XFILLER_44_170 VPWR VGND VPWR VGND sky130_ef_sc_hd__decap_12
X_1457_ net108 _0594_ _0595_ VGND VGND VPWR VPWR _0596_ sky130_fd_sc_hd__nor3_1
X_1526_ _0629_ _0663_ VGND VGND VPWR VPWR _0665_ sky130_fd_sc_hd__xnor2_1
X_1388_ _0525_ _0526_ VGND VGND VPWR VPWR _0527_ sky130_fd_sc_hd__nor2_1
X_2009_ net167 net5 VGND VGND VPWR VPWR _1148_ sky130_fd_sc_hd__nand2_1
XFILLER_2_247 VGND VGND VPWR VPWR sky130_fd_sc_hd__decap_4
XFILLER_2_236 VGND VGND VPWR VPWR sky130_fd_sc_hd__fill_2
XFILLER_33_118 VPWR VGND VPWR VGND sky130_ef_sc_hd__decap_12
XFILLER_41_81 VGND VGND VPWR VPWR sky130_fd_sc_hd__decap_8
XFILLER_25_82 VGND VGND VPWR VPWR sky130_fd_sc_hd__decap_8
XFILLER_44_6 VPWR VGND VPWR VGND sky130_ef_sc_hd__decap_12
X_2291_ net87 _0285_ net91 VGND VGND VPWR VPWR _0286_ sky130_fd_sc_hd__a21o_1
X_2360_ clknet_2_2__leaf_clk _0000_ net137 VGND VGND VPWR VPWR net44 sky130_fd_sc_hd__dfrtp_1
X_1311_ _0446_ _0449_ _0435_ VGND VGND VPWR VPWR _0450_ sky130_fd_sc_hd__o21a_1
XFILLER_2_53 VGND VGND VPWR VPWR sky130_fd_sc_hd__decap_8
X_1242_ net95 _0380_ VGND VGND VPWR VPWR _0381_ sky130_fd_sc_hd__and2_1
XPHY_EDGE_ROW_10_Right_10 VGND VGND VPWR VPWR sky130_fd_sc_hd__decap_3
X_1509_ _0646_ _0647_ VGND VGND VPWR VPWR _0648_ sky130_fd_sc_hd__nand2b_1
XFILLER_46_37 VGND VGND VPWR VPWR sky130_fd_sc_hd__fill_2
XFILLER_46_26 VGND VGND VPWR VPWR sky130_fd_sc_hd__fill_2
XPHY_EDGE_ROW_26_Left_76 VGND VGND VPWR VPWR sky130_fd_sc_hd__decap_3
X_1860_ net151 net191 _0996_ _0997_ VGND VGND VPWR VPWR _0999_ sky130_fd_sc_hd__o2bb2a_1
XFILLER_14_184 VPWR VGND VPWR VGND sky130_ef_sc_hd__decap_12
Xinput12 a_in[5] VGND VGND VPWR VPWR net12 sky130_fd_sc_hd__buf_1
Xinput23 b_in[6] VGND VGND VPWR VPWR net23 sky130_fd_sc_hd__clkbuf_1
X_1791_ _0926_ _0927_ _0901_ _0914_ VGND VGND VPWR VPWR _0930_ sky130_fd_sc_hd__a211o_1
X_2274_ _0087_ _0090_ _0136_ VGND VGND VPWR VPWR _0273_ sky130_fd_sc_hd__nand3_1
X_2343_ net249 net111 net99 net180 VGND VGND VPWR VPWR _0039_ sky130_fd_sc_hd__a22o_1
X_2412_ clknet_2_2__leaf_clk _0052_ net137 VGND VGND VPWR VPWR net80 sky130_fd_sc_hd__dfrtp_1
XFILLER_37_254 VGND VGND VPWR VPWR sky130_fd_sc_hd__decap_8
X_1225_ _0359_ _0363_ VGND VGND VPWR VPWR _0364_ sky130_fd_sc_hd__and2_1
X_1989_ _1125_ _1126_ _0867_ VGND VGND VPWR VPWR _1128_ sky130_fd_sc_hd__a21o_1
XTAP_TAPCELL_ROW_15_190 VGND VPWR sky130_fd_sc_hd__tapvpwrvgnd_1
XFILLER_4_309 VGND VGND VPWR VPWR sky130_fd_sc_hd__decap_8
XTAP_TAPCELL_ROW_7_147 VGND VPWR sky130_fd_sc_hd__tapvpwrvgnd_1
XFILLER_28_287 VGND VGND VPWR VPWR sky130_fd_sc_hd__decap_6
XFILLER_11_187 VGND VGND VPWR VPWR sky130_fd_sc_hd__decap_8
XFILLER_22_83 VGND VGND VPWR VPWR sky130_fd_sc_hd__fill_1
XFILLER_19_254 VGND VGND VPWR VPWR sky130_fd_sc_hd__fill_2
XFILLER_34_279 VGND VGND VPWR VPWR sky130_fd_sc_hd__decap_3
X_1912_ _1049_ _1050_ net165 net190 VGND VGND VPWR VPWR _1051_ sky130_fd_sc_hd__and4bb_1
XFILLER_8_63 VGND VGND VPWR VPWR sky130_fd_sc_hd__fill_1
XTAP_TAPCELL_ROW_12_171 VGND VPWR sky130_fd_sc_hd__tapvpwrvgnd_1
X_1843_ _0974_ _0981_ _0980_ VGND VGND VPWR VPWR _0982_ sky130_fd_sc_hd__a21bo_1
X_1774_ _0904_ _0912_ VGND VGND VPWR VPWR _0913_ sky130_fd_sc_hd__xnor2_1
X_2257_ _0872_ _1088_ VGND VGND VPWR VPWR _0260_ sky130_fd_sc_hd__and2b_1
XTAP_TAPCELL_ROW_4_128 VGND VPWR sky130_fd_sc_hd__tapvpwrvgnd_1
X_2326_ net279 net113 net101 _0312_ VGND VGND VPWR VPWR _0028_ sky130_fd_sc_hd__a22o_1
X_1208_ _0345_ _0346_ net105 VGND VGND VPWR VPWR _0347_ sky130_fd_sc_hd__o21a_1
XFILLER_40_238 VGND VGND VPWR VPWR sky130_fd_sc_hd__decap_8
XFILLER_33_290 VGND VGND VPWR VPWR sky130_fd_sc_hd__fill_1
X_2188_ _0180_ _0202_ VGND VGND VPWR VPWR _0203_ sky130_fd_sc_hd__and2_1
XTAP_TAPCELL_ROW_18_208 VGND VPWR sky130_fd_sc_hd__tapvpwrvgnd_1
XTAP_TAPCELL_ROW_26_252 VGND VPWR sky130_fd_sc_hd__tapvpwrvgnd_1
X_1490_ _0619_ _0621_ VGND VGND VPWR VPWR _0629_ sky130_fd_sc_hd__xor2_1
X_2111_ _0118_ _0125_ VGND VGND VPWR VPWR _0126_ sky130_fd_sc_hd__nand2_1
X_2042_ net156 net131 net5 net163 VGND VGND VPWR VPWR _0057_ sky130_fd_sc_hd__a22oi_1
XTAP_TAPCELL_ROW_49_377 VGND VPWR sky130_fd_sc_hd__tapvpwrvgnd_1
XPHY_EDGE_ROW_8_Right_8 VGND VGND VPWR VPWR sky130_fd_sc_hd__decap_3
X_1826_ _0963_ _0964_ VGND VGND VPWR VPWR _0965_ sky130_fd_sc_hd__and2b_1
XPHY_EDGE_ROW_39_Right_39 VGND VGND VPWR VPWR sky130_fd_sc_hd__decap_3
X_1688_ _0812_ _0825_ _0826_ _0761_ VGND VGND VPWR VPWR _0827_ sky130_fd_sc_hd__o211a_1
XFILLER_1_109 VGND VGND VPWR VPWR sky130_fd_sc_hd__decap_3
XPHY_EDGE_ROW_13_Left_63 VGND VGND VPWR VPWR sky130_fd_sc_hd__decap_3
X_1757_ _0798_ _0799_ VGND VGND VPWR VPWR _0896_ sky130_fd_sc_hd__xnor2_1
XFILLER_38_49 VGND VGND VPWR VPWR sky130_fd_sc_hd__fill_2
X_2309_ net277 net114 _0299_ net102 VGND VGND VPWR VPWR _0024_ sky130_fd_sc_hd__a22o_1
XPHY_EDGE_ROW_48_Right_48 VGND VGND VPWR VPWR sky130_fd_sc_hd__decap_3
XTAP_TAPCELL_ROW_23_233 VGND VPWR sky130_fd_sc_hd__tapvpwrvgnd_1
XTAP_TAPCELL_ROW_46_358 VGND VPWR sky130_fd_sc_hd__tapvpwrvgnd_1
XFILLER_44_70 VGND VGND VPWR VPWR sky130_fd_sc_hd__fill_2
X_1611_ net225 net158 net45 VGND VGND VPWR VPWR _0750_ sky130_fd_sc_hd__a21oi_1
XFILLER_8_253 VGND VGND VPWR VPWR sky130_fd_sc_hd__decap_6
X_1542_ _0678_ _0679_ _0673_ VGND VGND VPWR VPWR _0681_ sky130_fd_sc_hd__a21bo_1
X_1473_ _0609_ _0610_ _0608_ VGND VGND VPWR VPWR _0612_ sky130_fd_sc_hd__o21ba_1
XFILLER_39_113 VGND VGND VPWR VPWR sky130_fd_sc_hd__decap_8
X_2025_ _1131_ _1162_ _1163_ VGND VGND VPWR VPWR _1164_ sky130_fd_sc_hd__and3_1
X_1809_ _0796_ _0795_ _0827_ _0829_ VGND VGND VPWR VPWR _0948_ sky130_fd_sc_hd__a211o_1
XFILLER_49_15 VPWR VGND VPWR VGND sky130_ef_sc_hd__decap_12
XFILLER_5_289 VGND VGND VPWR VPWR sky130_fd_sc_hd__decap_6
XFILLER_36_149 VGND VGND VPWR VPWR sky130_fd_sc_hd__fill_2
XFILLER_36_116 VPWR VGND VPWR VGND sky130_ef_sc_hd__decap_12
XFILLER_44_182 VGND VGND VPWR VPWR sky130_fd_sc_hd__decap_8
X_1456_ net174 net124 net52 VGND VGND VPWR VPWR _0595_ sky130_fd_sc_hd__a21oi_1
X_1525_ _0663_ _0629_ VGND VGND VPWR VPWR _0664_ sky130_fd_sc_hd__and2b_1
X_1387_ _0505_ _0514_ VGND VGND VPWR VPWR _0526_ sky130_fd_sc_hd__xor2_1
X_2008_ _1145_ _1146_ VGND VGND VPWR VPWR _1147_ sky130_fd_sc_hd__xnor2_1
XFILLER_42_119 VGND VGND VPWR VPWR sky130_fd_sc_hd__fill_1
XFILLER_27_149 VGND VGND VPWR VPWR sky130_fd_sc_hd__decap_6
XFILLER_33_108 VGND VGND VPWR VPWR sky130_fd_sc_hd__decap_4
XFILLER_26_193 VGND VGND VPWR VPWR sky130_fd_sc_hd__decap_3
XFILLER_25_61 VGND VGND VPWR VPWR sky130_fd_sc_hd__fill_1
X_2290_ _0704_ _0284_ VGND VGND VPWR VPWR _0285_ sky130_fd_sc_hd__xnor2_1
XFILLER_1_281 VPWR VGND VPWR VGND sky130_ef_sc_hd__decap_12
X_1241_ _0374_ _0378_ VGND VGND VPWR VPWR _0380_ sky130_fd_sc_hd__xor2_1
X_1310_ _0339_ _0448_ VGND VGND VPWR VPWR _0449_ sky130_fd_sc_hd__nor2_1
XFILLER_32_141 VPWR VGND VPWR VGND sky130_ef_sc_hd__decap_12
X_1508_ _0609_ _0611_ VGND VGND VPWR VPWR _0647_ sky130_fd_sc_hd__xnor2_1
X_1439_ _0575_ _0576_ _0574_ VGND VGND VPWR VPWR _0578_ sky130_fd_sc_hd__o21ba_1
XFILLER_11_30 VPWR VGND VPWR VGND sky130_ef_sc_hd__decap_12
XFILLER_2_3 VPWR VGND VPWR VGND sky130_ef_sc_hd__decap_12
XPHY_EDGE_ROW_1_Left_51 VGND VGND VPWR VPWR sky130_fd_sc_hd__decap_3
Xinput13 a_in[6] VGND VGND VPWR VPWR net13 sky130_fd_sc_hd__buf_1
X_1790_ _0904_ _0912_ _0911_ VGND VGND VPWR VPWR _0929_ sky130_fd_sc_hd__a21o_1
XFILLER_14_141 VGND VGND VPWR VPWR sky130_fd_sc_hd__decap_4
Xinput24 b_in[7] VGND VGND VPWR VPWR net24 sky130_fd_sc_hd__buf_1
X_2411_ clknet_2_2__leaf_clk _0051_ net137 VGND VGND VPWR VPWR net79 sky130_fd_sc_hd__dfrtp_1
XFILLER_37_222 VGND VGND VPWR VPWR sky130_fd_sc_hd__fill_2
X_2273_ _0087_ _0090_ _0136_ VGND VGND VPWR VPWR _0272_ sky130_fd_sc_hd__a21o_1
X_1224_ _0360_ _0362_ VGND VGND VPWR VPWR _0363_ sky130_fd_sc_hd__or2_1
X_2342_ net252 net111 net99 net182 VGND VGND VPWR VPWR _0038_ sky130_fd_sc_hd__a22o_1
X_1988_ _0867_ _1125_ _1126_ VGND VGND VPWR VPWR _1127_ sky130_fd_sc_hd__and3_1
XTAP_TAPCELL_ROW_15_191 VGND VPWR sky130_fd_sc_hd__tapvpwrvgnd_1
XTAP_TAPCELL_ROW_7_148 VGND VPWR sky130_fd_sc_hd__tapvpwrvgnd_1
XPHY_EDGE_ROW_43_Left_93 VGND VGND VPWR VPWR sky130_fd_sc_hd__decap_3
XFILLER_28_266 VGND VGND VPWR VPWR sky130_fd_sc_hd__decap_4
Xclkbuf_2_2__f_clk clknet_0_clk VGND VGND VPWR VPWR clknet_2_2__leaf_clk sky130_fd_sc_hd__clkbuf_16
XFILLER_7_148 VGND VGND VPWR VPWR sky130_fd_sc_hd__fill_2
Xfanout190 net191 VGND VGND VPWR VPWR net190 sky130_fd_sc_hd__clkbuf_2
XFILLER_19_200 VGND VGND VPWR VPWR sky130_fd_sc_hd__fill_1
XFILLER_47_81 VGND VGND VPWR VPWR sky130_fd_sc_hd__decap_4
XFILLER_19_299 VGND VGND VPWR VPWR sky130_fd_sc_hd__fill_1
X_1911_ net169 net120 net55 VGND VGND VPWR VPWR _1050_ sky130_fd_sc_hd__a21oi_1
X_1773_ _0906_ _0910_ VGND VGND VPWR VPWR _0912_ sky130_fd_sc_hd__xor2_1
XTAP_TAPCELL_ROW_12_172 VGND VPWR sky130_fd_sc_hd__tapvpwrvgnd_1
X_1842_ _0978_ _0979_ VGND VGND VPWR VPWR _0981_ sky130_fd_sc_hd__xnor2_1
XFILLER_6_181 VGND VGND VPWR VPWR sky130_fd_sc_hd__decap_3
X_2256_ net46 net112 net100 _0259_ VGND VGND VPWR VPWR _0011_ sky130_fd_sc_hd__a22o_1
XTAP_TAPCELL_ROW_4_129 VGND VPWR sky130_fd_sc_hd__tapvpwrvgnd_1
X_1207_ net67 _0344_ VGND VGND VPWR VPWR _0346_ sky130_fd_sc_hd__nor2_1
X_2187_ _0200_ _0201_ VGND VGND VPWR VPWR _0202_ sky130_fd_sc_hd__nor2_1
X_2325_ net85 _0310_ _0311_ net89 VGND VGND VPWR VPWR _0312_ sky130_fd_sc_hd__a31o_1
XFILLER_48_317 VGND VGND VPWR VPWR sky130_fd_sc_hd__decap_3
XTAP_TAPCELL_ROW_26_253 VGND VPWR sky130_fd_sc_hd__tapvpwrvgnd_1
XFILLER_17_51 VGND VGND VPWR VPWR sky130_fd_sc_hd__decap_4
XTAP_TAPCELL_ROW_18_209 VGND VPWR sky130_fd_sc_hd__tapvpwrvgnd_1
XTAP_TAPCELL_ROW_49_378 VGND VPWR sky130_fd_sc_hd__tapvpwrvgnd_1
X_2041_ _1177_ _1178_ VGND VGND VPWR VPWR _0056_ sky130_fd_sc_hd__xnor2_1
X_2110_ _0115_ _0117_ _0116_ VGND VGND VPWR VPWR _0125_ sky130_fd_sc_hd__a21o_1
X_1825_ net154 net117 net188 net160 VGND VGND VPWR VPWR _0964_ sky130_fd_sc_hd__a22o_1
X_1756_ _0893_ _0894_ VGND VGND VPWR VPWR _0895_ sky130_fd_sc_hd__nor2_1
X_1687_ _0758_ _0760_ _0759_ VGND VGND VPWR VPWR _0826_ sky130_fd_sc_hd__a21o_1
X_2308_ net85 _0298_ net89 VGND VGND VPWR VPWR _0299_ sky130_fd_sc_hd__a21o_1
XTAP_TAPCELL_ROW_0_110 VGND VPWR sky130_fd_sc_hd__tapvpwrvgnd_1
X_2239_ _1024_ _1080_ VGND VGND VPWR VPWR _0247_ sky130_fd_sc_hd__nand2_1
XTAP_TAPCELL_ROW_23_234 VGND VPWR sky130_fd_sc_hd__tapvpwrvgnd_1
XFILLER_36_309 VGND VGND VPWR VPWR sky130_fd_sc_hd__decap_6
XFILLER_28_83 VGND VGND VPWR VPWR sky130_fd_sc_hd__fill_1
XTAP_TAPCELL_ROW_46_359 VGND VPWR sky130_fd_sc_hd__tapvpwrvgnd_1
XFILLER_44_82 VGND VGND VPWR VPWR sky130_fd_sc_hd__fill_2
X_1610_ net170 net158 net45 VGND VGND VPWR VPWR _0749_ sky130_fd_sc_hd__and3_4
XPHY_EDGE_ROW_30_Left_80 VGND VGND VPWR VPWR sky130_fd_sc_hd__decap_3
X_1541_ _0673_ _0678_ _0679_ VGND VGND VPWR VPWR _0680_ sky130_fd_sc_hd__nand3_1
X_1472_ _0608_ _0610_ VGND VGND VPWR VPWR _0611_ sky130_fd_sc_hd__nor2_1
X_2024_ _1160_ _1161_ _1117_ _1119_ VGND VGND VPWR VPWR _1163_ sky130_fd_sc_hd__a211o_1
XFILLER_40_18 VGND VGND VPWR VPWR sky130_fd_sc_hd__decap_8
XFILLER_10_209 VGND VGND VPWR VPWR sky130_fd_sc_hd__decap_6
XTAP_TAPCELL_ROW_20_215 VGND VPWR sky130_fd_sc_hd__tapvpwrvgnd_1
XFILLER_49_27 VGND VGND VPWR VPWR sky130_fd_sc_hd__fill_1
XFILLER_40_29 VGND VGND VPWR VPWR sky130_fd_sc_hd__decap_4
X_1739_ net169 net182 net72 VGND VGND VPWR VPWR _0878_ sky130_fd_sc_hd__and3_1
X_1808_ _0945_ _0946_ VGND VGND VPWR VPWR _0947_ sky130_fd_sc_hd__or2_1
XFILLER_45_128 VGND VGND VPWR VPWR sky130_fd_sc_hd__decap_8
XFILLER_38_191 VGND VGND VPWR VPWR sky130_fd_sc_hd__decap_4
XFILLER_36_139 VGND VGND VPWR VPWR sky130_fd_sc_hd__fill_1
XFILLER_36_128 VGND VGND VPWR VPWR sky130_fd_sc_hd__fill_1
XFILLER_44_194 VGND VGND VPWR VPWR sky130_fd_sc_hd__fill_2
XTAP_TAPCELL_ROW_42_340 VGND VPWR sky130_fd_sc_hd__tapvpwrvgnd_1
X_1524_ _0661_ _0662_ _0660_ VGND VGND VPWR VPWR _0663_ sky130_fd_sc_hd__a21oi_1
X_1455_ net174 net124 net52 VGND VGND VPWR VPWR _0594_ sky130_fd_sc_hd__and3_1
X_1386_ _0519_ _0523_ VGND VGND VPWR VPWR _0525_ sky130_fd_sc_hd__xor2_1
X_2007_ net153 net159 VGND VGND VPWR VPWR _1146_ sky130_fd_sc_hd__nand2_1
XFILLER_49_253 VGND VGND VPWR VPWR sky130_fd_sc_hd__fill_2
XFILLER_37_7 VGND VGND VPWR VPWR sky130_fd_sc_hd__fill_1
XFILLER_1_293 VPWR VGND VPWR VGND sky130_ef_sc_hd__decap_12
X_1240_ _0374_ _0378_ VGND VGND VPWR VPWR _0379_ sky130_fd_sc_hd__and2_1
XFILLER_17_161 VGND VGND VPWR VPWR sky130_fd_sc_hd__decap_6
XFILLER_32_153 VGND VGND VPWR VPWR sky130_fd_sc_hd__fill_1
X_1507_ _0637_ _0640_ _0638_ VGND VGND VPWR VPWR _0646_ sky130_fd_sc_hd__o21ba_1
X_1369_ net173 net124 net54 VGND VGND VPWR VPWR _0508_ sky130_fd_sc_hd__a21oi_1
X_1438_ _0574_ _0576_ VGND VGND VPWR VPWR _0577_ sky130_fd_sc_hd__or2_1
XFILLER_7_319 VGND VGND VPWR VPWR sky130_fd_sc_hd__fill_1
XFILLER_11_42 VGND VGND VPWR VPWR sky130_fd_sc_hd__decap_4
XFILLER_36_83 VGND VGND VPWR VPWR sky130_fd_sc_hd__fill_1
Xinput14 a_in[7] VGND VGND VPWR VPWR net14 sky130_fd_sc_hd__buf_1
XFILLER_14_197 VGND VGND VPWR VPWR sky130_fd_sc_hd__fill_1
Xinput25 clear_acc VGND VGND VPWR VPWR net25 sky130_fd_sc_hd__clkbuf_1
X_2410_ clknet_2_2__leaf_clk _0050_ net137 VGND VGND VPWR VPWR net78 sky130_fd_sc_hd__dfrtp_1
X_2341_ net266 net111 net99 net184 VGND VGND VPWR VPWR _0037_ sky130_fd_sc_hd__a22o_1
X_2272_ net50 net116 net104 _0271_ VGND VGND VPWR VPWR _0015_ sky130_fd_sc_hd__a22o_1
X_1223_ net105 _0360_ _0361_ VGND VGND VPWR VPWR _0362_ sky130_fd_sc_hd__nor3_1
X_1987_ _1123_ _1124_ _0863_ _0865_ VGND VGND VPWR VPWR _1126_ sky130_fd_sc_hd__a211o_1
XTAP_TAPCELL_ROW_15_192 VGND VPWR sky130_fd_sc_hd__tapvpwrvgnd_1
XFILLER_11_123 VGND VGND VPWR VPWR sky130_fd_sc_hd__fill_2
XFILLER_11_167 VGND VGND VPWR VPWR sky130_fd_sc_hd__fill_1
XFILLER_22_63 VPWR VGND VPWR VGND sky130_ef_sc_hd__decap_12
XFILLER_22_85 VGND VGND VPWR VPWR sky130_fd_sc_hd__fill_2
Xfanout180 net14 VGND VGND VPWR VPWR net180 sky130_fd_sc_hd__buf_2
Xfanout191 net1 VGND VGND VPWR VPWR net191 sky130_fd_sc_hd__clkbuf_2
X_1910_ net169 net120 net55 VGND VGND VPWR VPWR _1049_ sky130_fd_sc_hd__and3_1
XFILLER_19_289 VGND VGND VPWR VPWR sky130_fd_sc_hd__decap_6
XFILLER_8_21 VGND VGND VPWR VPWR sky130_fd_sc_hd__fill_1
X_1772_ _0906_ _0910_ VGND VGND VPWR VPWR _0911_ sky130_fd_sc_hd__and2_1
XTAP_TAPCELL_ROW_12_173 VGND VPWR sky130_fd_sc_hd__tapvpwrvgnd_1
X_1841_ _0979_ _0978_ VGND VGND VPWR VPWR _0980_ sky130_fd_sc_hd__nand2b_1
X_2324_ _0197_ _0205_ VGND VGND VPWR VPWR _0311_ sky130_fd_sc_hd__nand2_1
X_2255_ net86 _0258_ net90 VGND VGND VPWR VPWR _0259_ sky130_fd_sc_hd__a21o_1
X_1206_ net172 net121 net67 VGND VGND VPWR VPWR _0345_ sky130_fd_sc_hd__and3_1
X_2186_ _0198_ _0199_ VGND VGND VPWR VPWR _0201_ sky130_fd_sc_hd__and2b_1
XFILLER_40_207 VGND VGND VPWR VPWR sky130_fd_sc_hd__decap_4
XTAP_TAPCELL_ROW_35_298 VGND VPWR sky130_fd_sc_hd__tapvpwrvgnd_1
XFILLER_48_307 VGND VGND VPWR VPWR sky130_fd_sc_hd__fill_1
XFILLER_31_207 VGND VGND VPWR VPWR sky130_fd_sc_hd__fill_1
XTAP_TAPCELL_ROW_49_379 VGND VPWR sky130_fd_sc_hd__tapvpwrvgnd_1
X_2040_ _1178_ VGND VGND VPWR VPWR _1179_ sky130_fd_sc_hd__inv_2
XFILLER_22_229 VGND VGND VPWR VPWR sky130_fd_sc_hd__decap_6
X_1824_ net160 net154 net117 net188 VGND VGND VPWR VPWR _0963_ sky130_fd_sc_hd__and4_1
X_1755_ net154 net187 _0891_ _0892_ VGND VGND VPWR VPWR _0894_ sky130_fd_sc_hd__o2bb2a_1
X_1686_ _0812_ _0823_ _0824_ VGND VGND VPWR VPWR _0825_ sky130_fd_sc_hd__nor3_4
X_2238_ net72 net111 net99 _0246_ VGND VGND VPWR VPWR _0006_ sky130_fd_sc_hd__a22o_1
X_2307_ _0145_ _0297_ VGND VGND VPWR VPWR _0298_ sky130_fd_sc_hd__nor2_1
XTAP_TAPCELL_ROW_0_100 VGND VPWR sky130_fd_sc_hd__tapvpwrvgnd_1
XFILLER_13_229 VGND VGND VPWR VPWR sky130_fd_sc_hd__fill_1
X_2169_ _0183_ _0182_ VGND VGND VPWR VPWR _0184_ sky130_fd_sc_hd__and2b_1
XFILLER_21_295 VGND VGND VPWR VPWR sky130_fd_sc_hd__fill_1
XTAP_TAPCELL_ROW_23_235 VGND VPWR sky130_fd_sc_hd__tapvpwrvgnd_1
XFILLER_48_148 VGND VGND VPWR VPWR sky130_fd_sc_hd__decap_3
XFILLER_12_251 VGND VGND VPWR VPWR sky130_fd_sc_hd__fill_1
X_1540_ _0635_ _0669_ _0670_ _0672_ VGND VGND VPWR VPWR _0679_ sky130_fd_sc_hd__o211ai_2
XFILLER_5_55 VGND VGND VPWR VPWR sky130_fd_sc_hd__fill_1
XFILLER_8_222 VGND VGND VPWR VPWR sky130_fd_sc_hd__decap_8
XFILLER_39_137 VGND VGND VPWR VPWR sky130_fd_sc_hd__decap_3
X_1471_ net144 net130 net129 net149 VGND VGND VPWR VPWR _0610_ sky130_fd_sc_hd__a22oi_1
XFILLER_10_3 VGND VGND VPWR VPWR sky130_fd_sc_hd__fill_2
X_2023_ _1117_ _1119_ _1160_ _1161_ VGND VGND VPWR VPWR _1162_ sky130_fd_sc_hd__o211ai_1
X_1807_ _0943_ _0944_ _0941_ VGND VGND VPWR VPWR _0946_ sky130_fd_sc_hd__o21ba_1
XTAP_TAPCELL_ROW_20_216 VGND VPWR sky130_fd_sc_hd__tapvpwrvgnd_1
X_1738_ net164 net184 VGND VGND VPWR VPWR _0877_ sky130_fd_sc_hd__nand2_1
X_1669_ _0733_ _0801_ _0800_ _0797_ VGND VGND VPWR VPWR _0808_ sky130_fd_sc_hd__a211o_1
XFILLER_30_85 VGND VGND VPWR VPWR sky130_fd_sc_hd__decap_3
XTAP_TAPCELL_ROW_42_341 VGND VPWR sky130_fd_sc_hd__tapvpwrvgnd_1
X_1454_ _0562_ _0563_ net106 VGND VGND VPWR VPWR _0593_ sky130_fd_sc_hd__o21ai_1
X_1523_ _0630_ _0659_ VGND VGND VPWR VPWR _0662_ sky130_fd_sc_hd__xnor2_1
X_1385_ _0523_ _0519_ VGND VGND VPWR VPWR _0524_ sky130_fd_sc_hd__and2b_1
X_2006_ _1143_ _1144_ VGND VGND VPWR VPWR _1145_ sky130_fd_sc_hd__nor2_1
XFILLER_41_165 VGND VGND VPWR VPWR sky130_fd_sc_hd__decap_3
XFILLER_41_121 VGND VGND VPWR VPWR sky130_fd_sc_hd__fill_1
X_1506_ _0602_ _0631_ _0644_ VGND VGND VPWR VPWR _0645_ sky130_fd_sc_hd__nand3_1
X_1437_ net144 net129 net127 net149 VGND VGND VPWR VPWR _0576_ sky130_fd_sc_hd__a22oi_1
XFILLER_46_29 VGND VGND VPWR VPWR sky130_fd_sc_hd__decap_8
XFILLER_46_18 VGND VGND VPWR VPWR sky130_fd_sc_hd__decap_8
X_1368_ net173 net123 net54 VGND VGND VPWR VPWR _0507_ sky130_fd_sc_hd__and3_1
X_1299_ _0417_ _0437_ VGND VGND VPWR VPWR _0438_ sky130_fd_sc_hd__nor2_1
XFILLER_11_10 VGND VGND VPWR VPWR sky130_fd_sc_hd__fill_1
XFILLER_11_54 VGND VGND VPWR VPWR sky130_fd_sc_hd__fill_2
XFILLER_36_40 VGND VGND VPWR VPWR sky130_fd_sc_hd__fill_2
Xinput15 a_in[8] VGND VGND VPWR VPWR net15 sky130_fd_sc_hd__buf_1
Xinput26 en VGND VGND VPWR VPWR net26 sky130_fd_sc_hd__clkbuf_1
XFILLER_42_6 VPWR VGND VPWR VGND sky130_ef_sc_hd__decap_12
X_2271_ net86 _0270_ net90 VGND VGND VPWR VPWR _0271_ sky130_fd_sc_hd__a21o_1
X_2340_ net267 net111 net99 net186 VGND VGND VPWR VPWR _0036_ sky130_fd_sc_hd__a22o_1
XFILLER_37_279 VGND VGND VPWR VPWR sky130_fd_sc_hd__fill_1
X_1222_ net64 _0344_ VGND VGND VPWR VPWR _0361_ sky130_fd_sc_hd__nor2_1
X_1986_ _0863_ _0865_ _1123_ _1124_ VGND VGND VPWR VPWR _1125_ sky130_fd_sc_hd__o211ai_2
XFILLER_43_216 VGND VGND VPWR VPWR sky130_fd_sc_hd__decap_8
XFILLER_43_205 VGND VGND VPWR VPWR sky130_fd_sc_hd__fill_1
XFILLER_28_224 VGND VGND VPWR VPWR sky130_fd_sc_hd__fill_1
XFILLER_11_113 VGND VGND VPWR VPWR sky130_fd_sc_hd__decap_4
XFILLER_22_75 VGND VGND VPWR VPWR sky130_fd_sc_hd__decap_8
Xfanout181 net14 VGND VGND VPWR VPWR net181 sky130_fd_sc_hd__dlymetal6s2s_1
Xfanout170 net175 VGND VGND VPWR VPWR net170 sky130_fd_sc_hd__buf_8
XFILLER_19_268 VPWR VGND VPWR VGND sky130_ef_sc_hd__decap_12
XFILLER_42_282 VPWR VGND VPWR VGND sky130_ef_sc_hd__decap_12
XFILLER_8_11 VGND VGND VPWR VPWR sky130_fd_sc_hd__decap_3
XFILLER_8_33 VGND VGND VPWR VPWR sky130_fd_sc_hd__fill_1
X_1840_ _0902_ _0913_ VGND VGND VPWR VPWR _0979_ sky130_fd_sc_hd__xnor2_1
X_1771_ _0903_ _0909_ VGND VGND VPWR VPWR _0910_ sky130_fd_sc_hd__xnor2_1
XTAP_TAPCELL_ROW_12_174 VGND VPWR sky130_fd_sc_hd__tapvpwrvgnd_1
X_2254_ _0952_ _0257_ VGND VGND VPWR VPWR _0258_ sky130_fd_sc_hd__xnor2_1
X_2323_ _0197_ _0205_ VGND VGND VPWR VPWR _0310_ sky130_fd_sc_hd__or2_1
XFILLER_25_205 VPWR VGND VPWR VGND sky130_ef_sc_hd__decap_12
X_1205_ net172 net121 VGND VGND VPWR VPWR _0344_ sky130_fd_sc_hd__and2_2
X_2185_ _0199_ _0198_ VGND VGND VPWR VPWR _0200_ sky130_fd_sc_hd__and2b_1
X_1969_ _1106_ _1107_ net167 net130 VGND VGND VPWR VPWR _1108_ sky130_fd_sc_hd__and4bb_1
XTAP_TAPCELL_ROW_35_299 VGND VPWR sky130_fd_sc_hd__tapvpwrvgnd_1
XFILLER_17_20 VGND VGND VPWR VPWR sky130_fd_sc_hd__decap_6
XFILLER_16_227 VGND VGND VPWR VPWR sky130_fd_sc_hd__decap_4
XFILLER_16_249 VGND VGND VPWR VPWR sky130_fd_sc_hd__decap_3
XFILLER_33_63 VGND VGND VPWR VPWR sky130_fd_sc_hd__fill_1
XTAP_TAPCELL_ROW_17_200 VGND VPWR sky130_fd_sc_hd__tapvpwrvgnd_1
X_1823_ net151 net119 VGND VGND VPWR VPWR _0962_ sky130_fd_sc_hd__nand2_1
X_1754_ _0891_ _0892_ net154 net187 VGND VGND VPWR VPWR _0893_ sky130_fd_sc_hd__and4bb_1
X_1685_ _0742_ _0811_ _0810_ VGND VGND VPWR VPWR _0824_ sky130_fd_sc_hd__a21oi_1
XTAP_TAPCELL_ROW_0_101 VGND VPWR sky130_fd_sc_hd__tapvpwrvgnd_1
X_2237_ net84 _0245_ net88 VGND VGND VPWR VPWR _0246_ sky130_fd_sc_hd__a21o_1
X_2306_ _0556_ _0143_ _0144_ VGND VGND VPWR VPWR _0297_ sky130_fd_sc_hd__and3_1
X_2099_ _0096_ _0104_ _0103_ VGND VGND VPWR VPWR _0114_ sky130_fd_sc_hd__a21oi_1
X_2168_ net93 _0159_ _0157_ VGND VGND VPWR VPWR _0183_ sky130_fd_sc_hd__a21oi_1
XTAP_TAPCELL_ROW_23_236 VGND VPWR sky130_fd_sc_hd__tapvpwrvgnd_1
XTAP_TAPCELL_ROW_31_280 VGND VPWR sky130_fd_sc_hd__tapvpwrvgnd_1
XPHY_EDGE_ROW_17_Right_17 VGND VGND VPWR VPWR sky130_fd_sc_hd__decap_3
XPHY_EDGE_ROW_26_Right_26 VGND VGND VPWR VPWR sky130_fd_sc_hd__decap_3
XFILLER_28_85 VGND VGND VPWR VPWR sky130_fd_sc_hd__fill_2
XPHY_EDGE_ROW_35_Right_35 VGND VGND VPWR VPWR sky130_fd_sc_hd__decap_3
XFILLER_8_201 VPWR VGND VPWR VGND sky130_ef_sc_hd__decap_12
X_1470_ net142 _0325_ VGND VGND VPWR VPWR _0609_ sky130_fd_sc_hd__nand2_1
XFILLER_8_289 VGND VGND VPWR VPWR sky130_fd_sc_hd__fill_1
XPHY_EDGE_ROW_44_Right_44 VGND VGND VPWR VPWR sky130_fd_sc_hd__decap_3
X_2022_ _1158_ _1159_ _1142_ VGND VGND VPWR VPWR _1161_ sky130_fd_sc_hd__a21o_1
XPHY_EDGE_ROW_17_Left_67 VGND VGND VPWR VPWR sky130_fd_sc_hd__decap_3
XTAP_TAPCELL_ROW_20_217 VGND VPWR sky130_fd_sc_hd__tapvpwrvgnd_1
X_1806_ _0943_ _0944_ _0941_ VGND VGND VPWR VPWR _0945_ sky130_fd_sc_hd__nor3b_1
XFILLER_49_29 VPWR VGND VPWR VGND sky130_ef_sc_hd__decap_12
X_1599_ _0734_ _0735_ net166 net178 VGND VGND VPWR VPWR _0738_ sky130_fd_sc_hd__a2bb2o_1
X_1737_ _0319_ _0873_ _0322_ _0875_ VGND VGND VPWR VPWR _0876_ sky130_fd_sc_hd__or4_4
X_1668_ _0805_ _0806_ VGND VGND VPWR VPWR _0807_ sky130_fd_sc_hd__xnor2_1
XFILLER_14_43 VGND VGND VPWR VPWR sky130_fd_sc_hd__decap_6
XFILLER_14_65 VPWR VGND VPWR VGND sky130_ef_sc_hd__decap_12
XFILLER_39_73 VGND VGND VPWR VPWR sky130_fd_sc_hd__fill_1
X_1453_ net97 _0568_ VGND VGND VPWR VPWR _0592_ sky130_fd_sc_hd__xor2_1
X_1522_ _0648_ _0655_ VGND VGND VPWR VPWR _0661_ sky130_fd_sc_hd__nand2_1
X_2005_ net163 net156 net132 net131 VGND VGND VPWR VPWR _1144_ sky130_fd_sc_hd__and4_1
X_1384_ net127 _0328_ _0520_ _0521_ VGND VGND VPWR VPWR _0523_ sky130_fd_sc_hd__o2bb2a_1
XFILLER_35_185 VGND VGND VPWR VPWR sky130_fd_sc_hd__fill_2
XFILLER_35_163 VGND VGND VPWR VPWR sky130_fd_sc_hd__decap_4
XFILLER_41_188 VGND VGND VPWR VPWR sky130_fd_sc_hd__fill_1
XFILLER_41_74 VGND VGND VPWR VPWR sky130_fd_sc_hd__fill_1
XFILLER_20_306 VGND VGND VPWR VPWR sky130_fd_sc_hd__fill_2
X_1505_ _0641_ _0642_ _0636_ VGND VGND VPWR VPWR _0644_ sky130_fd_sc_hd__a21bo_1
X_1367_ _0488_ _0489_ net107 VGND VGND VPWR VPWR _0506_ sky130_fd_sc_hd__o21ai_1
X_1436_ net130 net142 VGND VGND VPWR VPWR _0575_ sky130_fd_sc_hd__nand2b_1
X_1298_ _0415_ _0416_ net109 VGND VGND VPWR VPWR _0437_ sky130_fd_sc_hd__o21a_1
XFILLER_36_74 VGND VGND VPWR VPWR sky130_fd_sc_hd__fill_2
Xinput16 a_in[9] VGND VGND VPWR VPWR net16 sky130_fd_sc_hd__buf_1
Xinput27 rst_n VGND VGND VPWR VPWR net27 sky130_fd_sc_hd__clkbuf_1
X_2270_ _0081_ _0269_ VGND VGND VPWR VPWR _0270_ sky130_fd_sc_hd__xor2_1
X_1221_ net172 net121 net64 VGND VGND VPWR VPWR _0360_ sky130_fd_sc_hd__and3_1
XFILLER_37_225 VPWR VGND VPWR VGND sky130_ef_sc_hd__decap_12
X_1985_ _1121_ _1122_ _0838_ _0841_ VGND VGND VPWR VPWR _1124_ sky130_fd_sc_hd__a211o_1
X_1419_ _0528_ _0529_ _0517_ _0524_ VGND VGND VPWR VPWR _0558_ sky130_fd_sc_hd__a211o_1
X_2399_ clknet_2_1__leaf_clk _0039_ net135 VGND VGND VPWR VPWR net41 sky130_fd_sc_hd__dfrtp_1
XFILLER_22_54 VGND VGND VPWR VPWR sky130_fd_sc_hd__decap_3
XPHY_EDGE_ROW_5_Left_55 VGND VGND VPWR VPWR sky130_fd_sc_hd__decap_3
XFILLER_0_3 VPWR VGND VPWR VGND sky130_ef_sc_hd__decap_12
XTAP_TAPCELL_ROW_6_140 VGND VPWR sky130_fd_sc_hd__tapvpwrvgnd_1
XFILLER_47_51 VGND VGND VPWR VPWR sky130_fd_sc_hd__decap_4
Xfanout171 net175 VGND VGND VPWR VPWR net171 sky130_fd_sc_hd__dlymetal6s2s_1
XFILLER_34_239 VGND VGND VPWR VPWR sky130_fd_sc_hd__fill_1
Xfanout182 net13 VGND VGND VPWR VPWR net182 sky130_fd_sc_hd__buf_2
Xfanout160 net19 VGND VGND VPWR VPWR net160 sky130_fd_sc_hd__buf_2
XFILLER_19_225 VGND VGND VPWR VPWR sky130_fd_sc_hd__decap_8
XFILLER_42_294 VPWR VGND VPWR VGND sky130_ef_sc_hd__decap_12
XFILLER_8_45 VGND VGND VPWR VPWR sky130_fd_sc_hd__fill_2
X_1770_ _0907_ _0908_ VGND VGND VPWR VPWR _0909_ sky130_fd_sc_hd__nor2_1
XTAP_TAPCELL_ROW_12_175 VGND VPWR sky130_fd_sc_hd__tapvpwrvgnd_1
X_2253_ _0946_ _1085_ _0945_ VGND VGND VPWR VPWR _0257_ sky130_fd_sc_hd__o21bai_1
X_2322_ net286 net114 net102 _0309_ VGND VGND VPWR VPWR _0027_ sky130_fd_sc_hd__a22o_1
X_2184_ net93 _0173_ _0172_ VGND VGND VPWR VPWR _0199_ sky130_fd_sc_hd__a21oi_1
X_1204_ net167 net121 VGND VGND VPWR VPWR _0343_ sky130_fd_sc_hd__nand2_1
XFILLER_25_217 VGND VGND VPWR VPWR sky130_fd_sc_hd__decap_6
XPHY_EDGE_ROW_47_Left_97 VGND VGND VPWR VPWR sky130_fd_sc_hd__decap_3
X_1968_ net171 net129 net48 VGND VGND VPWR VPWR _1107_ sky130_fd_sc_hd__a21oi_1
X_1899_ _1035_ _1036_ _1032_ VGND VGND VPWR VPWR _1038_ sky130_fd_sc_hd__a21o_1
XFILLER_0_305 VGND VGND VPWR VPWR sky130_fd_sc_hd__decap_3
XFILLER_48_309 VGND VGND VPWR VPWR sky130_fd_sc_hd__decap_8
XFILLER_24_261 VGND VGND VPWR VPWR sky130_fd_sc_hd__decap_3
XFILLER_15_261 VGND VGND VPWR VPWR sky130_fd_sc_hd__decap_8
XTAP_TAPCELL_ROW_17_201 VGND VPWR sky130_fd_sc_hd__tapvpwrvgnd_1
XFILLER_30_297 VGND VGND VPWR VPWR sky130_fd_sc_hd__decap_3
XFILLER_30_286 VGND VGND VPWR VPWR sky130_fd_sc_hd__fill_1
X_1822_ _0959_ _0876_ _0957_ _0955_ VGND VGND VPWR VPWR _0961_ sky130_fd_sc_hd__a211o_1
X_1753_ net160 net184 net182 net164 VGND VGND VPWR VPWR _0892_ sky130_fd_sc_hd__a22oi_1
X_1684_ _0816_ _0821_ VGND VGND VPWR VPWR _0823_ sky130_fd_sc_hd__xor2_1
XTAP_TAPCELL_ROW_48_370 VGND VPWR sky130_fd_sc_hd__tapvpwrvgnd_1
X_2305_ net272 net115 net103 _0296_ VGND VGND VPWR VPWR _0023_ sky130_fd_sc_hd__a22o_1
XTAP_TAPCELL_ROW_0_102 VGND VPWR sky130_fd_sc_hd__tapvpwrvgnd_1
X_2236_ _1071_ _1079_ VGND VGND VPWR VPWR _0245_ sky130_fd_sc_hd__xnor2_1
X_2167_ net92 _0178_ VGND VGND VPWR VPWR _0182_ sky130_fd_sc_hd__xor2_1
X_2098_ _0107_ _0108_ _0099_ _0102_ VGND VGND VPWR VPWR _0113_ sky130_fd_sc_hd__o211a_1
XFILLER_13_209 VGND VGND VPWR VPWR sky130_fd_sc_hd__fill_2
XFILLER_0_113 VGND VGND VPWR VPWR sky130_fd_sc_hd__fill_2
XFILLER_44_85 VPWR VGND VPWR VGND sky130_ef_sc_hd__decap_12
XFILLER_8_213 VGND VGND VPWR VPWR sky130_fd_sc_hd__decap_4
XFILLER_12_253 VPWR VGND VPWR VGND sky130_ef_sc_hd__decap_12
XFILLER_5_57 VGND VGND VPWR VPWR sky130_fd_sc_hd__decap_3
X_2021_ _1142_ _1158_ _1159_ VGND VGND VPWR VPWR _1160_ sky130_fd_sc_hd__nand3_1
X_1736_ net168 net184 net71 VGND VGND VPWR VPWR _0875_ sky130_fd_sc_hd__a21oi_1
XTAP_TAPCELL_ROW_20_218 VGND VPWR sky130_fd_sc_hd__tapvpwrvgnd_1
X_1805_ _0830_ _0942_ _0938_ _0935_ VGND VGND VPWR VPWR _0944_ sky130_fd_sc_hd__a211oi_1
X_1598_ _0319_ _0734_ _0735_ net178 VGND VGND VPWR VPWR _0737_ sky130_fd_sc_hd__or4b_4
X_1667_ net151 net187 VGND VGND VPWR VPWR _0806_ sky130_fd_sc_hd__nand2_1
XFILLER_38_183 VGND VGND VPWR VPWR sky130_fd_sc_hd__fill_1
X_2219_ _1052_ _1066_ _1065_ VGND VGND VPWR VPWR _0233_ sky130_fd_sc_hd__a21o_1
XFILLER_14_77 VGND VGND VPWR VPWR sky130_fd_sc_hd__decap_6
XFILLER_5_249 VGND VGND VPWR VPWR sky130_fd_sc_hd__decap_4
XFILLER_39_30 VGND VGND VPWR VPWR sky130_fd_sc_hd__decap_8
XPHY_EDGE_ROW_34_Left_84 VGND VGND VPWR VPWR sky130_fd_sc_hd__decap_3
XFILLER_29_161 VGND VGND VPWR VPWR sky130_fd_sc_hd__decap_6
X_1521_ _0630_ _0659_ VGND VGND VPWR VPWR _0660_ sky130_fd_sc_hd__and2b_1
X_1452_ _0581_ _0582_ VGND VGND VPWR VPWR _0591_ sky130_fd_sc_hd__nand2_1
X_1383_ net127 _0328_ _0521_ VGND VGND VPWR VPWR _0522_ sky130_fd_sc_hd__a21oi_1
X_2004_ net156 net133 net131 net163 VGND VGND VPWR VPWR _1143_ sky130_fd_sc_hd__a22oi_1
X_1719_ _0855_ _0856_ _0857_ VGND VGND VPWR VPWR _0858_ sky130_fd_sc_hd__nand3_2
XFILLER_41_145 VGND VGND VPWR VPWR sky130_fd_sc_hd__decap_6
XFILLER_41_101 VGND VGND VPWR VPWR sky130_fd_sc_hd__decap_3
XFILLER_26_120 VGND VGND VPWR VPWR sky130_fd_sc_hd__fill_1
XFILLER_41_31 VGND VGND VPWR VPWR sky130_fd_sc_hd__fill_1
XFILLER_49_223 VGND VGND VPWR VPWR sky130_fd_sc_hd__fill_1
XFILLER_32_167 VGND VGND VPWR VPWR sky130_fd_sc_hd__decap_3
XFILLER_32_134 VGND VGND VPWR VPWR sky130_fd_sc_hd__decap_6
X_1504_ _0636_ _0641_ _0642_ VGND VGND VPWR VPWR _0643_ sky130_fd_sc_hd__nand3_1
X_1366_ net97 _0494_ VGND VGND VPWR VPWR _0505_ sky130_fd_sc_hd__xor2_1
X_1435_ net149 net144 net129 net127 VGND VGND VPWR VPWR _0574_ sky130_fd_sc_hd__and4_1
X_1297_ net96 _0420_ VGND VGND VPWR VPWR _0436_ sky130_fd_sc_hd__xor2_1
XFILLER_23_167 VGND VGND VPWR VPWR sky130_fd_sc_hd__fill_1
XFILLER_46_259 VPWR VGND VPWR VGND sky130_ef_sc_hd__decap_12
Xinput17 b_in[0] VGND VGND VPWR VPWR net17 sky130_fd_sc_hd__buf_6
X_1220_ _0352_ _0358_ VGND VGND VPWR VPWR _0359_ sky130_fd_sc_hd__nor2_1
XFILLER_45_281 VPWR VGND VPWR VGND sky130_ef_sc_hd__decap_12
XFILLER_45_270 VGND VGND VPWR VPWR sky130_fd_sc_hd__decap_8
X_1984_ _0838_ _0841_ _1121_ _1122_ VGND VGND VPWR VPWR _1123_ sky130_fd_sc_hd__o211ai_2
XFILLER_20_104 VGND VGND VPWR VPWR sky130_fd_sc_hd__decap_3
XPHY_EDGE_ROW_21_Left_71 VGND VGND VPWR VPWR sky130_fd_sc_hd__decap_3
X_1349_ net173 net123 net56 VGND VGND VPWR VPWR _0488_ sky130_fd_sc_hd__and3_1
XFILLER_28_248 VGND VGND VPWR VPWR sky130_fd_sc_hd__decap_4
XFILLER_28_204 VGND VGND VPWR VPWR sky130_fd_sc_hd__decap_4
X_1418_ _0503_ _0531_ VGND VGND VPWR VPWR _0557_ sky130_fd_sc_hd__xor2_1
X_2398_ clknet_2_1__leaf_clk _0038_ net135 VGND VGND VPWR VPWR net40 sky130_fd_sc_hd__dfrtp_1
XFILLER_36_270 VGND VGND VPWR VPWR sky130_fd_sc_hd__fill_1
XFILLER_22_33 VGND VGND VPWR VPWR sky130_fd_sc_hd__fill_1
Xfanout183 net13 VGND VGND VPWR VPWR net183 sky130_fd_sc_hd__dlymetal6s2s_1
Xfanout150 net22 VGND VGND VPWR VPWR net150 sky130_fd_sc_hd__buf_2
XTAP_TAPCELL_ROW_6_141 VGND VPWR sky130_fd_sc_hd__tapvpwrvgnd_1
Xfanout161 net19 VGND VGND VPWR VPWR net161 sky130_fd_sc_hd__dlymetal6s2s_1
Xfanout172 net175 VGND VGND VPWR VPWR net172 sky130_fd_sc_hd__clkbuf_2
XFILLER_47_85 VGND VGND VPWR VPWR sky130_fd_sc_hd__fill_1
XTAP_TAPCELL_ROW_29_265 VGND VPWR sky130_fd_sc_hd__tapvpwrvgnd_1
XTAP_TAPCELL_ROW_12_176 VGND VPWR sky130_fd_sc_hd__tapvpwrvgnd_1
XFILLER_6_141 VGND VGND VPWR VPWR sky130_fd_sc_hd__fill_2
XFILLER_10_192 VGND VGND VPWR VPWR sky130_fd_sc_hd__decap_4
X_2321_ net85 _0307_ _0308_ net89 VGND VGND VPWR VPWR _0309_ sky130_fd_sc_hd__a31o_1
X_1203_ net153 _0331_ _0341_ VGND VGND VPWR VPWR _0342_ sky130_fd_sc_hd__a21boi_2
X_2252_ net45 net112 net100 _0256_ VGND VGND VPWR VPWR _0010_ sky130_fd_sc_hd__a22o_1
XFILLER_26_3 VGND VGND VPWR VPWR sky130_fd_sc_hd__fill_2
X_2183_ net93 _0452_ VGND VGND VPWR VPWR _0198_ sky130_fd_sc_hd__xor2_1
X_1967_ net171 net129 net48 VGND VGND VPWR VPWR _1106_ sky130_fd_sc_hd__and3_1
X_1898_ _1032_ _1036_ VGND VGND VPWR VPWR _1037_ sky130_fd_sc_hd__nand2b_1
XFILLER_0_317 VGND VGND VPWR VPWR sky130_fd_sc_hd__decap_3
XTAP_TAPCELL_ROW_3_122 VGND VPWR sky130_fd_sc_hd__tapvpwrvgnd_1
XFILLER_17_55 VGND VGND VPWR VPWR sky130_fd_sc_hd__fill_1
XFILLER_17_66 VGND VGND VPWR VPWR sky130_fd_sc_hd__decap_4
XFILLER_33_54 VGND VGND VPWR VPWR sky130_fd_sc_hd__fill_2
XFILLER_30_210 VGND VGND VPWR VPWR sky130_fd_sc_hd__decap_6
XTAP_TAPCELL_ROW_17_202 VGND VPWR sky130_fd_sc_hd__tapvpwrvgnd_1
X_1821_ _0955_ _0957_ _0959_ net197 VGND VGND VPWR VPWR _0960_ sky130_fd_sc_hd__o211ai_2
X_1752_ net164 net160 net184 net182 VGND VGND VPWR VPWR _0891_ sky130_fd_sc_hd__and4_1
X_1683_ _0821_ _0816_ VGND VGND VPWR VPWR _0822_ sky130_fd_sc_hd__nand2b_1
X_2304_ net87 _0295_ net91 VGND VGND VPWR VPWR _0296_ sky130_fd_sc_hd__a21o_1
XTAP_TAPCELL_ROW_48_371 VGND VPWR sky130_fd_sc_hd__tapvpwrvgnd_1
X_2097_ _0091_ _0111_ VGND VGND VPWR VPWR _0112_ sky130_fd_sc_hd__xnor2_1
XTAP_TAPCELL_ROW_0_103 VGND VPWR sky130_fd_sc_hd__tapvpwrvgnd_1
X_2235_ net71 net110 net98 _0244_ VGND VGND VPWR VPWR _0005_ sky130_fd_sc_hd__a22o_1
X_2166_ _0174_ _0179_ VGND VGND VPWR VPWR _0181_ sky130_fd_sc_hd__xnor2_1
XPHY_EDGE_ROW_3_Right_3 VGND VGND VPWR VPWR sky130_fd_sc_hd__decap_3
XFILLER_21_254 VGND VGND VPWR VPWR sky130_fd_sc_hd__decap_3
XFILLER_21_276 VGND VGND VPWR VPWR sky130_fd_sc_hd__decap_4
XFILLER_12_221 VGND VGND VPWR VPWR sky130_fd_sc_hd__fill_1
XFILLER_44_97 VGND VGND VPWR VPWR sky130_fd_sc_hd__fill_2
XFILLER_8_269 VGND VGND VPWR VPWR sky130_fd_sc_hd__fill_1
XFILLER_12_243 VGND VGND VPWR VPWR sky130_fd_sc_hd__fill_1
XFILLER_12_265 VGND VGND VPWR VPWR sky130_fd_sc_hd__decap_4
XFILLER_12_276 VGND VGND VPWR VPWR sky130_fd_sc_hd__fill_2
XFILLER_12_298 VGND VGND VPWR VPWR sky130_fd_sc_hd__fill_1
XFILLER_47_195 VPWR VGND VPWR VGND sky130_ef_sc_hd__decap_12
X_2020_ _1155_ _1156_ _1157_ VGND VGND VPWR VPWR _1159_ sky130_fd_sc_hd__a21o_1
XFILLER_35_302 VGND VGND VPWR VPWR sky130_fd_sc_hd__decap_6
XTAP_TAPCELL_ROW_20_219 VGND VPWR sky130_fd_sc_hd__tapvpwrvgnd_1
X_1735_ net168 net184 net71 VGND VGND VPWR VPWR _0874_ sky130_fd_sc_hd__nand3_1
X_1666_ _0803_ _0804_ VGND VGND VPWR VPWR _0805_ sky130_fd_sc_hd__and2b_1
X_1804_ _0935_ _0938_ _0942_ _0830_ VGND VGND VPWR VPWR _0943_ sky130_fd_sc_hd__o211a_1
X_1597_ _0734_ _0735_ net166 net178 VGND VGND VPWR VPWR _0736_ sky130_fd_sc_hd__and4bb_1
XFILLER_38_195 VGND VGND VPWR VPWR sky130_fd_sc_hd__fill_1
X_2218_ net275 net113 _0231_ net101 VGND VGND VPWR VPWR _0000_ sky130_fd_sc_hd__a22o_1
X_2149_ _0553_ _0163_ VGND VGND VPWR VPWR _0164_ sky130_fd_sc_hd__xnor2_2
XFILLER_30_44 VGND VGND VPWR VPWR sky130_fd_sc_hd__fill_1
XFILLER_5_239 VGND VGND VPWR VPWR sky130_fd_sc_hd__decap_4
XFILLER_29_140 VGND VGND VPWR VPWR sky130_fd_sc_hd__decap_8
X_1520_ _0645_ _0658_ VGND VGND VPWR VPWR _0659_ sky130_fd_sc_hd__nand2_1
X_1451_ _0586_ _0589_ VGND VGND VPWR VPWR _0590_ sky130_fd_sc_hd__or2_1
X_1382_ net144 net127 net125 net149 VGND VGND VPWR VPWR _0521_ sky130_fd_sc_hd__a22oi_1
XFILLER_4_261 VPWR VGND VPWR VGND sky130_ef_sc_hd__decap_12
X_2003_ _1139_ _1140_ VGND VGND VPWR VPWR _1142_ sky130_fd_sc_hd__xnor2_1
X_1718_ _0778_ net200 _0784_ VGND VGND VPWR VPWR _0857_ sky130_fd_sc_hd__a21bo_1
X_1649_ _0773_ _0786_ net203 VGND VGND VPWR VPWR _0788_ sky130_fd_sc_hd__nand3_4
XFILLER_6_90 VGND VGND VPWR VPWR sky130_fd_sc_hd__decap_8
XFILLER_41_113 VGND VGND VPWR VPWR sky130_fd_sc_hd__fill_2
XFILLER_25_55 VGND VGND VPWR VPWR sky130_fd_sc_hd__fill_1
XFILLER_2_15 VPWR VGND VPWR VGND sky130_ef_sc_hd__decap_12
XFILLER_49_279 VGND VGND VPWR VPWR sky130_fd_sc_hd__fill_1
XFILLER_17_121 VGND VGND VPWR VPWR sky130_fd_sc_hd__fill_2
XFILLER_17_198 VGND VGND VPWR VPWR sky130_fd_sc_hd__fill_1
XFILLER_20_319 VGND VGND VPWR VPWR sky130_fd_sc_hd__fill_1
X_1503_ _0597_ _0632_ _0633_ _0635_ VGND VGND VPWR VPWR _0642_ sky130_fd_sc_hd__a211o_1
X_1434_ _0332_ _0571_ VGND VGND VPWR VPWR _0573_ sky130_fd_sc_hd__xnor2_1
X_1365_ _0497_ _0498_ VGND VGND VPWR VPWR _0504_ sky130_fd_sc_hd__xor2_1
X_1296_ _0340_ _0424_ VGND VGND VPWR VPWR _0435_ sky130_fd_sc_hd__xnor2_1
XFILLER_23_102 VGND VGND VPWR VPWR sky130_fd_sc_hd__fill_1
XFILLER_46_238 VPWR VGND VPWR VGND sky130_ef_sc_hd__decap_12
XFILLER_46_205 VGND VGND VPWR VPWR sky130_fd_sc_hd__fill_2
XFILLER_36_32 VGND VGND VPWR VPWR sky130_fd_sc_hd__decap_8
Xinput18 b_in[1] VGND VGND VPWR VPWR net18 sky130_fd_sc_hd__buf_1
XFILLER_45_293 VPWR VGND VPWR VGND sky130_ef_sc_hd__decap_12
X_1983_ _1119_ _1120_ _0858_ _0861_ VGND VGND VPWR VPWR _1122_ sky130_fd_sc_hd__o211ai_2
XFILLER_9_172 VPWR VGND VPWR VGND sky130_ef_sc_hd__decap_12
X_1417_ _0532_ _0554_ VGND VGND VPWR VPWR _0556_ sky130_fd_sc_hd__xor2_1
X_1348_ _0474_ _0475_ net106 VGND VGND VPWR VPWR _0487_ sky130_fd_sc_hd__o21ai_1
XFILLER_28_216 VGND VGND VPWR VPWR sky130_fd_sc_hd__decap_8
X_1279_ _0415_ _0417_ VGND VGND VPWR VPWR _0418_ sky130_fd_sc_hd__or2_1
X_2397_ clknet_2_0__leaf_clk _0037_ net135 VGND VGND VPWR VPWR net39 sky130_fd_sc_hd__dfrtp_1
XFILLER_22_23 VGND VGND VPWR VPWR sky130_fd_sc_hd__fill_1
Xfanout162 net19 VGND VGND VPWR VPWR net162 sky130_fd_sc_hd__buf_2
Xfanout184 net12 VGND VGND VPWR VPWR net184 sky130_fd_sc_hd__buf_2
XTAP_TAPCELL_ROW_6_142 VGND VPWR sky130_fd_sc_hd__tapvpwrvgnd_1
Xfanout140 net27 VGND VGND VPWR VPWR net140 sky130_fd_sc_hd__buf_2
Xfanout151 net21 VGND VGND VPWR VPWR net151 sky130_fd_sc_hd__buf_2
Xfanout173 net174 VGND VGND VPWR VPWR net173 sky130_fd_sc_hd__clkbuf_2
XTAP_TAPCELL_ROW_29_266 VGND VPWR sky130_fd_sc_hd__tapvpwrvgnd_1
XFILLER_27_271 VGND VGND VPWR VPWR sky130_fd_sc_hd__fill_1
XFILLER_27_260 VGND VGND VPWR VPWR sky130_fd_sc_hd__fill_1
XFILLER_40_6 VPWR VGND VPWR VGND sky130_ef_sc_hd__decap_12
X_2251_ net86 _0254_ _0255_ net90 VGND VGND VPWR VPWR _0256_ sky130_fd_sc_hd__a31o_1
XFILLER_6_197 VGND VGND VPWR VPWR sky130_fd_sc_hd__decap_6
X_2320_ _0186_ _0306_ VGND VGND VPWR VPWR _0308_ sky130_fd_sc_hd__nand2_1
X_1202_ net152 net125 _0331_ VGND VGND VPWR VPWR _0341_ sky130_fd_sc_hd__a21o_1
X_2182_ _0192_ _0196_ VGND VGND VPWR VPWR _0197_ sky130_fd_sc_hd__and2_1
X_1966_ _1103_ _1104_ VGND VGND VPWR VPWR _1105_ sky130_fd_sc_hd__xnor2_1
XFILLER_33_252 VPWR VGND VPWR VGND sky130_ef_sc_hd__decap_12
X_1897_ _0992_ _1027_ _1028_ _1030_ VGND VGND VPWR VPWR _1036_ sky130_fd_sc_hd__a211o_1
XTAP_TAPCELL_ROW_3_123 VGND VPWR sky130_fd_sc_hd__tapvpwrvgnd_1
XFILLER_30_200 VGND VGND VPWR VPWR sky130_fd_sc_hd__decap_4
X_1820_ _0873_ _0875_ net164 net186 VGND VGND VPWR VPWR _0959_ sky130_fd_sc_hd__a2bb2o_1
XTAP_TAPCELL_ROW_17_203 VGND VPWR sky130_fd_sc_hd__tapvpwrvgnd_1
X_1751_ _0883_ _0888_ _0882_ VGND VGND VPWR VPWR _0890_ sky130_fd_sc_hd__a21bo_1
X_1682_ _0818_ _0819_ _0817_ VGND VGND VPWR VPWR _0821_ sky130_fd_sc_hd__o21ba_1
XFILLER_38_300 VGND VGND VPWR VPWR sky130_fd_sc_hd__decap_8
X_2303_ _0588_ _0294_ VGND VGND VPWR VPWR _0295_ sky130_fd_sc_hd__xor2_1
X_2234_ _1071_ net84 _0243_ net88 VGND VGND VPWR VPWR _0244_ sky130_fd_sc_hd__a31o_1
XTAP_TAPCELL_ROW_48_372 VGND VPWR sky130_fd_sc_hd__tapvpwrvgnd_1
X_2096_ _0110_ _0092_ VGND VGND VPWR VPWR _0111_ sky130_fd_sc_hd__nand2b_1
XTAP_TAPCELL_ROW_0_104 VGND VPWR sky130_fd_sc_hd__tapvpwrvgnd_1
X_2165_ _0179_ _0174_ VGND VGND VPWR VPWR _0180_ sky130_fd_sc_hd__and2b_1
XFILLER_9_90 VGND VGND VPWR VPWR sky130_fd_sc_hd__fill_1
X_1949_ _1083_ _1023_ _0954_ _1086_ _1087_ VGND VGND VPWR VPWR _1088_ sky130_fd_sc_hd__a311oi_2
XFILLER_28_11 VGND VGND VPWR VPWR sky130_fd_sc_hd__decap_4
XFILLER_44_43 VGND VGND VPWR VPWR sky130_fd_sc_hd__decap_4
XFILLER_5_15 VPWR VGND VPWR VGND sky130_ef_sc_hd__decap_12
XFILLER_8_237 VGND VGND VPWR VPWR sky130_fd_sc_hd__decap_8
XFILLER_47_163 VGND VGND VPWR VPWR sky130_fd_sc_hd__fill_1
XTAP_TAPCELL_ROW_45_353 VGND VPWR sky130_fd_sc_hd__tapvpwrvgnd_1
XTAP_TAPCELL_ROW_37_309 VGND VPWR sky130_fd_sc_hd__tapvpwrvgnd_1
XFILLER_35_314 VGND VGND VPWR VPWR sky130_fd_sc_hd__fill_2
XPHY_EDGE_ROW_13_Right_13 VGND VGND VPWR VPWR sky130_fd_sc_hd__decap_3
XPHY_EDGE_ROW_22_Right_22 VGND VGND VPWR VPWR sky130_fd_sc_hd__decap_3
X_1803_ _0827_ _0828_ _0815_ _0822_ VGND VGND VPWR VPWR _0942_ sky130_fd_sc_hd__o211ai_1
X_1596_ net223 net176 net75 VGND VGND VPWR VPWR _0735_ sky130_fd_sc_hd__a21oi_1
X_1734_ net168 net184 net71 VGND VGND VPWR VPWR _0873_ sky130_fd_sc_hd__and3_1
XFILLER_7_270 VGND VGND VPWR VPWR sky130_fd_sc_hd__decap_8
X_1665_ net154 net185 net182 net160 VGND VGND VPWR VPWR _0804_ sky130_fd_sc_hd__a22o_1
XFILLER_38_141 VGND VGND VPWR VPWR sky130_fd_sc_hd__decap_8
XPHY_EDGE_ROW_31_Right_31 VGND VGND VPWR VPWR sky130_fd_sc_hd__decap_3
X_2217_ net25 net114 VGND VGND VPWR VPWR _0232_ sky130_fd_sc_hd__nor2_1
XFILLER_41_306 VPWR VGND VPWR VGND sky130_ef_sc_hd__decap_12
X_2079_ _0673_ _0679_ _0678_ VGND VGND VPWR VPWR _0094_ sky130_fd_sc_hd__a21o_1
XFILLER_14_35 VGND VGND VPWR VPWR sky130_fd_sc_hd__fill_1
X_2148_ _0161_ _0162_ VGND VGND VPWR VPWR _0163_ sky130_fd_sc_hd__or2_1
XPHY_EDGE_ROW_40_Right_40 VGND VGND VPWR VPWR sky130_fd_sc_hd__decap_3
XFILLER_5_218 VGND VGND VPWR VPWR sky130_fd_sc_hd__fill_2
XFILLER_39_10 VGND VGND VPWR VPWR sky130_fd_sc_hd__decap_6
XFILLER_32_317 VGND VGND VPWR VPWR sky130_fd_sc_hd__decap_3
XFILLER_32_306 VGND VGND VPWR VPWR sky130_fd_sc_hd__fill_2
X_1450_ _0584_ _0585_ _0572_ _0579_ VGND VGND VPWR VPWR _0589_ sky130_fd_sc_hd__o211a_1
XFILLER_4_273 VPWR VGND VPWR VGND sky130_ef_sc_hd__decap_12
X_1381_ net129 net141 VGND VGND VPWR VPWR _0520_ sky130_fd_sc_hd__nand2b_1
X_2002_ _1140_ VGND VGND VPWR VPWR _1141_ sky130_fd_sc_hd__inv_2
XFILLER_35_199 VPWR VGND VPWR VGND sky130_ef_sc_hd__decap_12
XFILLER_35_177 VGND VGND VPWR VPWR sky130_fd_sc_hd__fill_1
XFILLER_35_100 VPWR VGND VPWR VGND sky130_ef_sc_hd__decap_12
X_1717_ _0853_ _0854_ _0847_ VGND VGND VPWR VPWR _0856_ sky130_fd_sc_hd__a21o_1
X_1648_ _0785_ _0784_ _0778_ VGND VGND VPWR VPWR _0787_ sky130_fd_sc_hd__a21o_1
X_1579_ net150 net145 net186 net184 VGND VGND VPWR VPWR _0718_ sky130_fd_sc_hd__and4_1
XFILLER_41_169 VGND VGND VPWR VPWR sky130_fd_sc_hd__fill_2
XFILLER_49_225 VPWR VGND VPWR VGND sky130_ef_sc_hd__decap_12
XFILLER_2_27 VGND VGND VPWR VPWR sky130_fd_sc_hd__fill_1
XFILLER_20_309 VGND VGND VPWR VPWR sky130_fd_sc_hd__fill_2
XFILLER_49_3 VPWR VGND VPWR VGND sky130_ef_sc_hd__decap_12
X_1502_ _0639_ _0640_ VGND VGND VPWR VPWR _0641_ sky130_fd_sc_hd__xnor2_1
X_1433_ _0333_ _0571_ VGND VGND VPWR VPWR _0572_ sky130_fd_sc_hd__nand2_1
X_1295_ net92 _0428_ VGND VGND VPWR VPWR _0434_ sky130_fd_sc_hd__xor2_1
X_1364_ _0460_ _0502_ VGND VGND VPWR VPWR _0503_ sky130_fd_sc_hd__xnor2_1
Xinput19 b_in[2] VGND VGND VPWR VPWR net19 sky130_fd_sc_hd__clkbuf_2
X_1982_ _0858_ _0861_ _1119_ _1120_ VGND VGND VPWR VPWR _1121_ sky130_fd_sc_hd__a211o_1
XFILLER_9_184 VGND VGND VPWR VPWR sky130_fd_sc_hd__fill_1
X_1347_ _0342_ _0479_ VGND VGND VPWR VPWR _0486_ sky130_fd_sc_hd__xnor2_1
X_1416_ _0532_ _0554_ VGND VGND VPWR VPWR _0555_ sky130_fd_sc_hd__nand2b_1
X_2396_ clknet_2_0__leaf_clk _0036_ net135 VGND VGND VPWR VPWR net38 sky130_fd_sc_hd__dfrtp_1
X_1278_ net109 _0415_ _0416_ VGND VGND VPWR VPWR _0417_ sky130_fd_sc_hd__nor3_1
XFILLER_22_46 VGND VGND VPWR VPWR sky130_fd_sc_hd__decap_8
XFILLER_3_305 VPWR VGND VPWR VGND sky130_ef_sc_hd__decap_12
Xfanout163 net19 VGND VGND VPWR VPWR net163 sky130_fd_sc_hd__buf_2
Xfanout185 net12 VGND VGND VPWR VPWR net185 sky130_fd_sc_hd__clkbuf_2
Xfanout130 net4 VGND VGND VPWR VPWR net130 sky130_fd_sc_hd__clkbuf_2
Xfanout152 net21 VGND VGND VPWR VPWR net152 sky130_fd_sc_hd__clkbuf_4
Xfanout174 net175 VGND VGND VPWR VPWR net174 sky130_fd_sc_hd__clkbuf_2
XTAP_TAPCELL_ROW_6_143 VGND VPWR sky130_fd_sc_hd__tapvpwrvgnd_1
Xfanout141 net24 VGND VGND VPWR VPWR net141 sky130_fd_sc_hd__clkbuf_4
XFILLER_42_242 VGND VGND VPWR VPWR sky130_fd_sc_hd__decap_6
XTAP_TAPCELL_ROW_29_267 VGND VPWR sky130_fd_sc_hd__tapvpwrvgnd_1
X_2250_ _0947_ _1085_ VGND VGND VPWR VPWR _0255_ sky130_fd_sc_hd__nand2_1
XFILLER_6_187 VGND VGND VPWR VPWR sky130_fd_sc_hd__fill_1
X_1201_ net94 VGND VGND VPWR VPWR _0340_ sky130_fd_sc_hd__clkinv_4
X_2181_ _0185_ _0194_ _0195_ VGND VGND VPWR VPWR _0196_ sky130_fd_sc_hd__and3_1
X_1965_ net152 net176 VGND VGND VPWR VPWR _1104_ sky130_fd_sc_hd__nand2_1
XFILLER_33_264 VGND VGND VPWR VPWR sky130_fd_sc_hd__fill_1
X_1896_ _1033_ _1034_ VGND VGND VPWR VPWR _1035_ sky130_fd_sc_hd__nor2_1
X_2379_ clknet_2_3__leaf_clk _0019_ net139 VGND VGND VPWR VPWR net54 sky130_fd_sc_hd__dfrtp_1
XTAP_TAPCELL_ROW_3_124 VGND VPWR sky130_fd_sc_hd__tapvpwrvgnd_1
XFILLER_17_13 VGND VGND VPWR VPWR sky130_fd_sc_hd__decap_4
XTAP_TAPCELL_ROW_26_248 VGND VPWR sky130_fd_sc_hd__tapvpwrvgnd_1
XFILLER_24_286 VGND VGND VPWR VPWR sky130_fd_sc_hd__decap_4
XFILLER_24_275 VGND VGND VPWR VPWR sky130_fd_sc_hd__decap_4
XFILLER_24_253 VGND VGND VPWR VPWR sky130_fd_sc_hd__decap_8
XFILLER_24_220 VGND VGND VPWR VPWR sky130_fd_sc_hd__decap_8
XPHY_EDGE_ROW_9_Left_59 VGND VGND VPWR VPWR sky130_fd_sc_hd__decap_3
XFILLER_17_57 VGND VGND VPWR VPWR sky130_fd_sc_hd__decap_6
XTAP_TAPCELL_ROW_34_292 VGND VPWR sky130_fd_sc_hd__tapvpwrvgnd_1
XFILLER_30_267 VGND VGND VPWR VPWR sky130_fd_sc_hd__fill_2
X_1750_ _0882_ _0883_ _0888_ VGND VGND VPWR VPWR _0889_ sky130_fd_sc_hd__nand3_1
X_1681_ _0817_ _0819_ VGND VGND VPWR VPWR _0820_ sky130_fd_sc_hd__nor2_1
X_2302_ _0627_ _0291_ _0626_ VGND VGND VPWR VPWR _0294_ sky130_fd_sc_hd__a21bo_1
X_2233_ _1046_ _1070_ _1060_ VGND VGND VPWR VPWR _0243_ sky130_fd_sc_hd__o21ai_1
X_2164_ net92 _0178_ _0176_ VGND VGND VPWR VPWR _0179_ sky130_fd_sc_hd__a21oi_1
XTAP_TAPCELL_ROW_48_373 VGND VPWR sky130_fd_sc_hd__tapvpwrvgnd_1
X_2095_ _0107_ _0109_ VGND VGND VPWR VPWR _0110_ sky130_fd_sc_hd__nor2_1
XFILLER_0_82 VGND VGND VPWR VPWR sky130_fd_sc_hd__fill_2
XTAP_TAPCELL_ROW_0_105 VGND VPWR sky130_fd_sc_hd__tapvpwrvgnd_1
X_1879_ net190 net141 VGND VGND VPWR VPWR _1018_ sky130_fd_sc_hd__and2b_1
XFILLER_21_223 VGND VGND VPWR VPWR sky130_fd_sc_hd__fill_1
X_1948_ _0945_ _0951_ _0949_ VGND VGND VPWR VPWR _1087_ sky130_fd_sc_hd__a21o_1
XFILLER_29_301 VGND VGND VPWR VPWR sky130_fd_sc_hd__decap_8
XFILLER_28_23 VGND VGND VPWR VPWR sky130_fd_sc_hd__fill_1
XFILLER_44_55 VGND VGND VPWR VPWR sky130_fd_sc_hd__decap_3
XFILLER_5_27 VPWR VGND VPWR VGND sky130_ef_sc_hd__decap_12
XTAP_TAPCELL_ROW_45_354 VGND VPWR sky130_fd_sc_hd__tapvpwrvgnd_1
Xclkbuf_2_3__f_clk clknet_0_clk VGND VGND VPWR VPWR clknet_2_3__leaf_clk sky130_fd_sc_hd__clkbuf_16
X_1733_ _0870_ _0871_ VGND VGND VPWR VPWR _0872_ sky130_fd_sc_hd__nor2_1
X_1802_ _0932_ _0939_ _0940_ VGND VGND VPWR VPWR _0941_ sky130_fd_sc_hd__and3_1
X_1595_ net170 net176 net75 VGND VGND VPWR VPWR _0734_ sky130_fd_sc_hd__and3_1
X_1664_ net160 net154 net185 net182 VGND VGND VPWR VPWR _0803_ sky130_fd_sc_hd__and4_1
XFILLER_38_197 VGND VGND VPWR VPWR sky130_fd_sc_hd__decap_8
X_2216_ net84 _0230_ net88 VGND VGND VPWR VPWR _0231_ sky130_fd_sc_hd__a21o_1
X_2147_ _0547_ _0550_ _0160_ VGND VGND VPWR VPWR _0162_ sky130_fd_sc_hd__nor3_1
X_2078_ _0682_ _0694_ _0693_ VGND VGND VPWR VPWR _0093_ sky130_fd_sc_hd__o21ba_1
XFILLER_41_318 VGND VGND VPWR VPWR sky130_fd_sc_hd__fill_2
XFILLER_44_145 VPWR VGND VPWR VGND sky130_ef_sc_hd__decap_12
XFILLER_44_134 VGND VGND VPWR VPWR sky130_fd_sc_hd__decap_6
XFILLER_29_197 VGND VGND VPWR VPWR sky130_fd_sc_hd__decap_4
XFILLER_29_175 VGND VGND VPWR VPWR sky130_fd_sc_hd__fill_1
X_1380_ _0517_ _0518_ VGND VGND VPWR VPWR _0519_ sky130_fd_sc_hd__nor2_1
XFILLER_4_285 VPWR VGND VPWR VGND sky130_ef_sc_hd__decap_12
X_2001_ _1091_ _1093_ _1092_ VGND VGND VPWR VPWR _1140_ sky130_fd_sc_hd__o21ba_1
XFILLER_35_167 VGND VGND VPWR VPWR sky130_fd_sc_hd__fill_1
XFILLER_35_145 VGND VGND VPWR VPWR sky130_fd_sc_hd__fill_1
X_1716_ _0847_ _0853_ _0854_ VGND VGND VPWR VPWR _0855_ sky130_fd_sc_hd__nand3_1
X_1647_ _0778_ _0784_ net199 VGND VGND VPWR VPWR _0786_ sky130_fd_sc_hd__nand3_1
X_1578_ net141 _0321_ VGND VGND VPWR VPWR _0717_ sky130_fd_sc_hd__nand2_1
XFILLER_26_167 VPWR VGND VPWR VGND sky130_ef_sc_hd__decap_12
XFILLER_26_134 VGND VGND VPWR VPWR sky130_fd_sc_hd__fill_2
XFILLER_41_137 VGND VGND VPWR VPWR sky130_fd_sc_hd__fill_1
XFILLER_41_45 VGND VGND VPWR VPWR sky130_fd_sc_hd__fill_1
XFILLER_25_57 VGND VGND VPWR VPWR sky130_fd_sc_hd__decap_4
XFILLER_41_89 VGND VGND VPWR VPWR sky130_fd_sc_hd__fill_2
XPHY_EDGE_ROW_38_Left_88 VGND VGND VPWR VPWR sky130_fd_sc_hd__decap_3
XFILLER_9_3 VGND VGND VPWR VPWR sky130_fd_sc_hd__decap_8
XFILLER_49_259 VPWR VGND VPWR VGND sky130_ef_sc_hd__decap_12
XFILLER_49_237 VPWR VGND VPWR VGND sky130_ef_sc_hd__decap_12
XFILLER_1_277 VGND VGND VPWR VPWR sky130_fd_sc_hd__decap_3
XFILLER_32_159 VGND VGND VPWR VPWR sky130_fd_sc_hd__decap_8
XFILLER_17_167 VGND VGND VPWR VPWR sky130_fd_sc_hd__fill_1
X_1501_ net153 net129 VGND VGND VPWR VPWR _0640_ sky130_fd_sc_hd__nand2_1
X_1432_ _0520_ _0522_ VGND VGND VPWR VPWR _0571_ sky130_fd_sc_hd__xnor2_1
X_1363_ _0485_ _0500_ VGND VGND VPWR VPWR _0502_ sky130_fd_sc_hd__xnor2_1
X_1294_ _0430_ _0432_ VGND VGND VPWR VPWR _0433_ sky130_fd_sc_hd__nor2_1
XFILLER_31_192 VGND VGND VPWR VPWR sky130_fd_sc_hd__decap_6
XFILLER_39_270 VGND VGND VPWR VPWR sky130_fd_sc_hd__decap_3
XFILLER_39_281 VGND VGND VPWR VPWR sky130_fd_sc_hd__fill_2
XFILLER_36_56 VGND VGND VPWR VPWR sky130_fd_sc_hd__decap_4
XFILLER_22_192 VGND VGND VPWR VPWR sky130_fd_sc_hd__decap_4
X_1981_ _1116_ _1118_ _1100_ VGND VGND VPWR VPWR _1120_ sky130_fd_sc_hd__a21oi_1
XFILLER_13_181 VGND VGND VPWR VPWR sky130_fd_sc_hd__decap_6
XFILLER_3_82 VGND VGND VPWR VPWR sky130_fd_sc_hd__fill_2
X_2395_ clknet_2_0__leaf_clk _0035_ net134 VGND VGND VPWR VPWR net37 sky130_fd_sc_hd__dfrtp_1
X_1346_ _0340_ _0483_ VGND VGND VPWR VPWR _0485_ sky130_fd_sc_hd__xnor2_1
X_1415_ _0551_ _0552_ VGND VGND VPWR VPWR _0554_ sky130_fd_sc_hd__xnor2_1
X_1277_ net62 _0344_ VGND VGND VPWR VPWR _0416_ sky130_fd_sc_hd__nor2_1
Xfanout131 net4 VGND VGND VPWR VPWR net131 sky130_fd_sc_hd__dlymetal6s2s_1
Xfanout120 net8 VGND VGND VPWR VPWR net120 sky130_fd_sc_hd__dlymetal6s2s_1
XFILLER_3_317 VGND VGND VPWR VPWR sky130_fd_sc_hd__decap_3
XFILLER_47_55 VGND VGND VPWR VPWR sky130_fd_sc_hd__fill_1
Xfanout153 net21 VGND VGND VPWR VPWR net153 sky130_fd_sc_hd__clkbuf_2
Xfanout142 net24 VGND VGND VPWR VPWR net142 sky130_fd_sc_hd__buf_2
XTAP_TAPCELL_ROW_29_268 VGND VPWR sky130_fd_sc_hd__tapvpwrvgnd_1
Xfanout164 net18 VGND VGND VPWR VPWR net164 sky130_fd_sc_hd__clkbuf_2
Xfanout175 net17 VGND VGND VPWR VPWR net175 sky130_fd_sc_hd__buf_12
Xfanout186 net11 VGND VGND VPWR VPWR net186 sky130_fd_sc_hd__buf_2
XFILLER_42_232 VGND VGND VPWR VPWR sky130_fd_sc_hd__fill_2
XFILLER_8_38 VGND VGND VPWR VPWR sky130_fd_sc_hd__decap_4
X_2180_ _0181_ _0184_ _0188_ VGND VGND VPWR VPWR _0195_ sky130_fd_sc_hd__o21ai_1
X_1200_ _0328_ _0338_ VGND VGND VPWR VPWR _0339_ sky130_fd_sc_hd__xnor2_1
XFILLER_33_221 VGND VGND VPWR VPWR sky130_fd_sc_hd__decap_3
XPHY_EDGE_ROW_25_Left_75 VGND VGND VPWR VPWR sky130_fd_sc_hd__decap_3
XFILLER_18_251 VGND VGND VPWR VPWR sky130_fd_sc_hd__fill_1
X_1964_ _1101_ _1102_ VGND VGND VPWR VPWR _1103_ sky130_fd_sc_hd__nor2_1
X_1895_ net161 net154 net191 net120 VGND VGND VPWR VPWR _1034_ sky130_fd_sc_hd__and4_1
XFILLER_0_309 VGND VGND VPWR VPWR sky130_fd_sc_hd__decap_8
X_2378_ clknet_2_3__leaf_clk _0018_ net139 VGND VGND VPWR VPWR net53 sky130_fd_sc_hd__dfrtp_1
X_1329_ net106 _0466_ _0465_ VGND VGND VPWR VPWR _0468_ sky130_fd_sc_hd__o21ba_1
XTAP_TAPCELL_ROW_3_125 VGND VPWR sky130_fd_sc_hd__tapvpwrvgnd_1
XFILLER_17_36 VGND VGND VPWR VPWR sky130_fd_sc_hd__decap_8
XTAP_TAPCELL_ROW_34_293 VGND VPWR sky130_fd_sc_hd__tapvpwrvgnd_1
XFILLER_33_57 VGND VGND VPWR VPWR sky130_fd_sc_hd__decap_6
XFILLER_33_24 VPWR VGND VPWR VGND sky130_ef_sc_hd__decap_12
XTAP_TAPCELL_ROW_26_249 VGND VPWR sky130_fd_sc_hd__tapvpwrvgnd_1
XFILLER_15_210 VGND VGND VPWR VPWR sky130_fd_sc_hd__decap_4
XFILLER_15_221 VGND VGND VPWR VPWR sky130_fd_sc_hd__decap_3
X_2301_ net274 net115 net103 _0293_ VGND VGND VPWR VPWR _0022_ sky130_fd_sc_hd__a22o_1
X_1680_ net143 net117 net189 net147 VGND VGND VPWR VPWR _0819_ sky130_fd_sc_hd__a22oi_1
X_2232_ net287 net110 net98 _0242_ VGND VGND VPWR VPWR _0004_ sky130_fd_sc_hd__a22o_1
XTAP_TAPCELL_ROW_0_106 VGND VPWR sky130_fd_sc_hd__tapvpwrvgnd_1
X_2163_ _0176_ _0177_ VGND VGND VPWR VPWR _0178_ sky130_fd_sc_hd__nor2_1
XTAP_TAPCELL_ROW_48_374 VGND VPWR sky130_fd_sc_hd__tapvpwrvgnd_1
X_2094_ _0099_ _0102_ _0107_ _0108_ VGND VGND VPWR VPWR _0109_ sky130_fd_sc_hd__a211oi_2
XFILLER_21_202 VGND VGND VPWR VPWR sky130_fd_sc_hd__decap_3
XFILLER_21_246 VGND VGND VPWR VPWR sky130_fd_sc_hd__decap_8
XFILLER_9_70 VGND VGND VPWR VPWR sky130_fd_sc_hd__fill_2
X_1878_ _1016_ _1015_ VGND VGND VPWR VPWR _1017_ sky130_fd_sc_hd__and2b_1
XFILLER_21_268 VGND VGND VPWR VPWR sky130_fd_sc_hd__fill_1
X_1947_ _0984_ _1021_ _0953_ _0987_ VGND VGND VPWR VPWR _1086_ sky130_fd_sc_hd__a211oi_2
XFILLER_0_139 VGND VGND VPWR VPWR sky130_fd_sc_hd__fill_1
XFILLER_28_35 VGND VGND VPWR VPWR sky130_fd_sc_hd__fill_1
XFILLER_8_217 VGND VGND VPWR VPWR sky130_fd_sc_hd__fill_1
XTAP_TAPCELL_ROW_22_230 VGND VPWR sky130_fd_sc_hd__tapvpwrvgnd_1
XFILLER_5_39 VGND VGND VPWR VPWR sky130_fd_sc_hd__fill_2
XTAP_TAPCELL_ROW_45_355 VGND VPWR sky130_fd_sc_hd__tapvpwrvgnd_1
X_1732_ _0831_ _0869_ VGND VGND VPWR VPWR _0871_ sky130_fd_sc_hd__and2_1
X_1663_ _0797_ _0800_ _0801_ _0733_ VGND VGND VPWR VPWR _0802_ sky130_fd_sc_hd__o211ai_2
X_1801_ _0936_ _0937_ _0933_ VGND VGND VPWR VPWR _0940_ sky130_fd_sc_hd__a21bo_1
XFILLER_7_294 VGND VGND VPWR VPWR sky130_fd_sc_hd__fill_2
XPHY_EDGE_ROW_7_Right_7 VGND VGND VPWR VPWR sky130_fd_sc_hd__decap_3
X_1594_ _0319_ _0730_ _0731_ net180 VGND VGND VPWR VPWR _0733_ sky130_fd_sc_hd__or4b_4
X_2077_ _0697_ _0699_ VGND VGND VPWR VPWR _0092_ sky130_fd_sc_hd__xnor2_1
X_2215_ _1065_ _0229_ VGND VGND VPWR VPWR _0230_ sky130_fd_sc_hd__nor2_1
X_2146_ _0547_ _0550_ _0160_ VGND VGND VPWR VPWR _0161_ sky130_fd_sc_hd__o21a_1
XFILLER_14_26 VGND VGND VPWR VPWR sky130_fd_sc_hd__fill_2
XPHY_EDGE_ROW_12_Left_62 VGND VGND VPWR VPWR sky130_fd_sc_hd__decap_3
XFILLER_39_23 VGND VGND VPWR VPWR sky130_fd_sc_hd__fill_1
XFILLER_44_102 VGND VGND VPWR VPWR sky130_fd_sc_hd__decap_3
XTAP_TAPCELL_ROW_42_336 VGND VPWR sky130_fd_sc_hd__tapvpwrvgnd_1
XFILLER_4_297 VGND VGND VPWR VPWR sky130_fd_sc_hd__decap_8
X_2000_ _1132_ _1137_ VGND VGND VPWR VPWR _1139_ sky130_fd_sc_hd__xnor2_1
XFILLER_35_157 VGND VGND VPWR VPWR sky130_fd_sc_hd__decap_3
X_1715_ _0851_ _0852_ _0779_ _0781_ VGND VGND VPWR VPWR _0854_ sky130_fd_sc_hd__a211o_1
X_1646_ _0783_ _0782_ _0749_ _0751_ VGND VGND VPWR VPWR _0785_ sky130_fd_sc_hd__a211o_1
X_1577_ net152 net184 _0713_ _0712_ VGND VGND VPWR VPWR _0716_ sky130_fd_sc_hd__a31o_1
Xrebuffer10 _0790_ VGND VGND VPWR VPWR net201 sky130_fd_sc_hd__clkbuf_1
X_2129_ _0628_ _0711_ _0142_ _0709_ _0710_ VGND VGND VPWR VPWR _0144_ sky130_fd_sc_hd__o221a_1
Xrebuffer32 net170 VGND VGND VPWR VPWR net223 sky130_fd_sc_hd__dlymetal6s2s_1
XFILLER_26_179 VGND VGND VPWR VPWR sky130_fd_sc_hd__fill_1
XFILLER_25_25 VGND VGND VPWR VPWR sky130_fd_sc_hd__decap_4
XFILLER_41_68 VGND VGND VPWR VPWR sky130_fd_sc_hd__decap_6
XFILLER_49_249 VGND VGND VPWR VPWR sky130_fd_sc_hd__decap_3
XFILLER_2_29 VPWR VGND VPWR VGND sky130_ef_sc_hd__decap_12
XFILLER_17_113 VGND VGND VPWR VPWR sky130_fd_sc_hd__decap_8
X_1500_ _0637_ _0638_ VGND VGND VPWR VPWR _0639_ sky130_fd_sc_hd__nor2_1
X_1431_ _0569_ _0560_ VGND VGND VPWR VPWR _0570_ sky130_fd_sc_hd__nand2b_1
X_1293_ _0410_ _0429_ VGND VGND VPWR VPWR _0432_ sky130_fd_sc_hd__and2b_1
X_1362_ _0500_ _0485_ VGND VGND VPWR VPWR _0501_ sky130_fd_sc_hd__and2b_1
X_1629_ _0762_ _0767_ VGND VGND VPWR VPWR _0768_ sky130_fd_sc_hd__nand2_1
X_1980_ _1100_ _1116_ _1118_ VGND VGND VPWR VPWR _1119_ sky130_fd_sc_hd__and3_1
XFILLER_9_120 VGND VGND VPWR VPWR sky130_fd_sc_hd__fill_2
XTAP_TAPCELL_ROW_15_188 VGND VPWR sky130_fd_sc_hd__tapvpwrvgnd_1
Xrebuffer1 _0961_ VGND VGND VPWR VPWR net192 sky130_fd_sc_hd__dlymetal6s2s_1
XFILLER_9_197 VGND VGND VPWR VPWR sky130_fd_sc_hd__decap_6
X_2394_ clknet_2_0__leaf_clk _0034_ net134 VGND VGND VPWR VPWR net36 sky130_fd_sc_hd__dfrtp_1
X_1276_ net172 net122 net62 VGND VGND VPWR VPWR _0415_ sky130_fd_sc_hd__and3_1
X_1414_ _0552_ _0551_ VGND VGND VPWR VPWR _0553_ sky130_fd_sc_hd__nand2b_1
X_1345_ net94 _0483_ VGND VGND VPWR VPWR _0484_ sky130_fd_sc_hd__nor2_1
XFILLER_11_108 VGND VGND VPWR VPWR sky130_fd_sc_hd__decap_4
Xfanout132 net3 VGND VGND VPWR VPWR net132 sky130_fd_sc_hd__buf_2
Xfanout165 net18 VGND VGND VPWR VPWR net165 sky130_fd_sc_hd__dlymetal6s2s_1
Xfanout121 net126 VGND VGND VPWR VPWR net121 sky130_fd_sc_hd__buf_2
Xfanout110 net111 VGND VGND VPWR VPWR net110 sky130_fd_sc_hd__buf_2
Xfanout143 net146 VGND VGND VPWR VPWR net143 sky130_fd_sc_hd__buf_2
Xfanout154 net157 VGND VGND VPWR VPWR net154 sky130_fd_sc_hd__buf_2
Xfanout176 net16 VGND VGND VPWR VPWR net176 sky130_fd_sc_hd__buf_2
XTAP_TAPCELL_ROW_29_269 VGND VPWR sky130_fd_sc_hd__tapvpwrvgnd_1
XFILLER_19_208 VGND VGND VPWR VPWR sky130_fd_sc_hd__decap_4
Xfanout187 net11 VGND VGND VPWR VPWR net187 sky130_fd_sc_hd__buf_1
XPHY_EDGE_ROW_0_Left_50 VGND VGND VPWR VPWR sky130_fd_sc_hd__decap_3
XFILLER_12_81 VGND VGND VPWR VPWR sky130_fd_sc_hd__decap_3
X_1963_ net155 net159 net132 net162 VGND VGND VPWR VPWR _1102_ sky130_fd_sc_hd__a22oi_1
XFILLER_33_299 VGND VGND VPWR VPWR sky130_fd_sc_hd__fill_1
X_1894_ net154 net190 net120 net161 VGND VGND VPWR VPWR _1033_ sky130_fd_sc_hd__a22oi_1
X_2377_ clknet_2_3__leaf_clk _0017_ net139 VGND VGND VPWR VPWR net52 sky130_fd_sc_hd__dfrtp_1
X_1328_ _0465_ _0466_ VGND VGND VPWR VPWR _0467_ sky130_fd_sc_hd__nor2_1
XTAP_TAPCELL_ROW_3_126 VGND VPWR sky130_fd_sc_hd__tapvpwrvgnd_1
X_1259_ net95 _0397_ VGND VGND VPWR VPWR _0398_ sky130_fd_sc_hd__xor2_1
XFILLER_17_26 VGND VGND VPWR VPWR sky130_fd_sc_hd__fill_1
XTAP_TAPCELL_ROW_34_294 VGND VPWR sky130_fd_sc_hd__tapvpwrvgnd_1
XFILLER_33_36 VGND VGND VPWR VPWR sky130_fd_sc_hd__decap_8
XPHY_EDGE_ROW_42_Left_92 VGND VGND VPWR VPWR sky130_fd_sc_hd__decap_3
XFILLER_15_277 VGND VGND VPWR VPWR sky130_fd_sc_hd__decap_3
X_2300_ net87 _0292_ net91 VGND VGND VPWR VPWR _0293_ sky130_fd_sc_hd__a21o_1
X_2231_ net84 _0240_ _0241_ net88 VGND VGND VPWR VPWR _0242_ sky130_fd_sc_hd__a31o_1
X_2093_ _0695_ _0093_ _0096_ _0106_ VGND VGND VPWR VPWR _0108_ sky130_fd_sc_hd__o211a_1
XTAP_TAPCELL_ROW_0_107 VGND VPWR sky130_fd_sc_hd__tapvpwrvgnd_1
X_2162_ _0152_ _0155_ _0175_ VGND VGND VPWR VPWR _0177_ sky130_fd_sc_hd__nor3_1
XFILLER_21_225 VGND VGND VPWR VPWR sky130_fd_sc_hd__fill_1
X_1877_ _0974_ _0981_ VGND VGND VPWR VPWR _1016_ sky130_fd_sc_hd__xnor2_1
X_1946_ _1023_ _1083_ _1022_ VGND VGND VPWR VPWR _1085_ sky130_fd_sc_hd__a21oi_1
XFILLER_28_47 VGND VGND VPWR VPWR sky130_fd_sc_hd__fill_1
XFILLER_44_317 VGND VGND VPWR VPWR sky130_fd_sc_hd__decap_3
XFILLER_44_306 VGND VGND VPWR VPWR sky130_fd_sc_hd__fill_2
XTAP_TAPCELL_ROW_39_320 VGND VPWR sky130_fd_sc_hd__tapvpwrvgnd_1
XFILLER_12_225 VPWR VGND VPWR VGND sky130_ef_sc_hd__decap_12
XFILLER_12_247 VGND VGND VPWR VPWR sky130_fd_sc_hd__decap_4
XFILLER_12_269 VGND VGND VPWR VPWR sky130_fd_sc_hd__fill_1
XFILLER_20_280 VGND VGND VPWR VPWR sky130_fd_sc_hd__decap_8
XTAP_TAPCELL_ROW_22_231 VGND VPWR sky130_fd_sc_hd__tapvpwrvgnd_1
XFILLER_47_177 VGND VGND VPWR VPWR sky130_fd_sc_hd__decap_6
XFILLER_47_155 VGND VGND VPWR VPWR sky130_fd_sc_hd__decap_8
XTAP_TAPCELL_ROW_45_356 VGND VPWR sky130_fd_sc_hd__tapvpwrvgnd_1
X_1800_ _0933_ _0935_ _0937_ VGND VGND VPWR VPWR _0939_ sky130_fd_sc_hd__or3b_4
X_1731_ _0831_ _0869_ VGND VGND VPWR VPWR _0870_ sky130_fd_sc_hd__nor2_1
X_1662_ _0730_ _0731_ net166 net180 VGND VGND VPWR VPWR _0801_ sky130_fd_sc_hd__a2bb2o_1
X_1593_ _0730_ _0731_ net166 net180 VGND VGND VPWR VPWR _0732_ sky130_fd_sc_hd__and4bb_1
X_2214_ net169 net190 net44 VGND VGND VPWR VPWR _0229_ sky130_fd_sc_hd__a21oi_1
X_2076_ _0666_ _0700_ VGND VGND VPWR VPWR _0091_ sky130_fd_sc_hd__xnor2_1
X_2145_ net93 _0159_ VGND VGND VPWR VPWR _0160_ sky130_fd_sc_hd__xor2_1
X_1929_ _1067_ VGND VGND VPWR VPWR _1068_ sky130_fd_sc_hd__inv_2
XFILLER_14_49 VGND VGND VPWR VPWR sky130_fd_sc_hd__fill_1
XFILLER_39_57 VGND VGND VPWR VPWR sky130_fd_sc_hd__decap_3
XTAP_TAPCELL_ROW_42_337 VGND VPWR sky130_fd_sc_hd__tapvpwrvgnd_1
XFILLER_32_309 VGND VGND VPWR VPWR sky130_fd_sc_hd__decap_8
XFILLER_20_70 VGND VGND VPWR VPWR sky130_fd_sc_hd__decap_6
XFILLER_35_169 VGND VGND VPWR VPWR sky130_fd_sc_hd__decap_8
Xhold90 net33 VGND VGND VPWR VPWR net281 sky130_fd_sc_hd__dlygate4sd3_1
X_1714_ _0779_ _0781_ _0851_ _0852_ VGND VGND VPWR VPWR _0853_ sky130_fd_sc_hd__o211ai_2
X_1645_ _0749_ _0751_ _0782_ _0783_ VGND VGND VPWR VPWR _0784_ sky130_fd_sc_hd__o211ai_2
X_1576_ net152 net184 VGND VGND VPWR VPWR _0715_ sky130_fd_sc_hd__nand2_1
Xrebuffer11 _0948_ VGND VGND VPWR VPWR net202 sky130_fd_sc_hd__dlymetal6s4s_1
X_2059_ _1158_ _1160_ _0071_ _0073_ VGND VGND VPWR VPWR _0074_ sky130_fd_sc_hd__a211oi_1
Xrebuffer33 net225 VGND VGND VPWR VPWR net224 sky130_fd_sc_hd__buf_1
XFILLER_34_191 VGND VGND VPWR VPWR sky130_fd_sc_hd__decap_4
XFILLER_34_180 VGND VGND VPWR VPWR sky130_fd_sc_hd__fill_1
X_2128_ _0090_ _0087_ _0137_ _0709_ VGND VGND VPWR VPWR _0143_ sky130_fd_sc_hd__a211o_4
XFILLER_26_114 VGND VGND VPWR VPWR sky130_fd_sc_hd__decap_6
XFILLER_25_37 VPWR VGND VPWR VGND sky130_ef_sc_hd__decap_12
XFILLER_1_213 VGND VGND VPWR VPWR sky130_fd_sc_hd__fill_2
XFILLER_1_257 VPWR VGND VPWR VGND sky130_ef_sc_hd__decap_12
XFILLER_17_169 VGND VGND VPWR VPWR sky130_fd_sc_hd__decap_4
X_1430_ net97 _0568_ _0566_ VGND VGND VPWR VPWR _0569_ sky130_fd_sc_hd__a21oi_1
X_1361_ _0486_ _0495_ _0499_ VGND VGND VPWR VPWR _0500_ sky130_fd_sc_hd__o21a_1
Xoutput80 net80 VGND VGND VPWR VPWR b_out[4] sky130_fd_sc_hd__buf_2
X_1292_ _0409_ _0430_ VGND VGND VPWR VPWR _0431_ sky130_fd_sc_hd__xor2_1
XFILLER_23_128 VGND VGND VPWR VPWR sky130_fd_sc_hd__decap_3
X_1559_ _0658_ _0667_ _0682_ _0695_ VGND VGND VPWR VPWR _0698_ sky130_fd_sc_hd__a211oi_1
X_1628_ _0763_ _0766_ VGND VGND VPWR VPWR _0767_ sky130_fd_sc_hd__xnor2_1
XFILLER_39_250 VGND VGND VPWR VPWR sky130_fd_sc_hd__decap_4
XFILLER_14_106 VGND VGND VPWR VPWR sky130_fd_sc_hd__fill_1
XFILLER_14_117 VGND VGND VPWR VPWR sky130_fd_sc_hd__decap_6
XFILLER_22_150 VGND VGND VPWR VPWR sky130_fd_sc_hd__decap_3
Xrebuffer2 net207 VGND VGND VPWR VPWR net193 sky130_fd_sc_hd__clkbuf_2
XTAP_TAPCELL_ROW_15_189 VGND VPWR sky130_fd_sc_hd__tapvpwrvgnd_1
XFILLER_47_3 VPWR VGND VPWR VGND sky130_ef_sc_hd__decap_12
X_2393_ clknet_2_0__leaf_clk _0033_ net134 VGND VGND VPWR VPWR net35 sky130_fd_sc_hd__dfrtp_1
X_1413_ _0460_ _0502_ _0501_ VGND VGND VPWR VPWR _0552_ sky130_fd_sc_hd__a21oi_1
XFILLER_36_253 VPWR VGND VPWR VGND sky130_ef_sc_hd__decap_12
XFILLER_36_231 VGND VGND VPWR VPWR sky130_fd_sc_hd__decap_8
X_1344_ _0481_ _0482_ VGND VGND VPWR VPWR _0483_ sky130_fd_sc_hd__or2_1
XFILLER_3_51 VGND VGND VPWR VPWR sky130_fd_sc_hd__decap_4
X_1275_ _0377_ _0413_ VGND VGND VPWR VPWR _0414_ sky130_fd_sc_hd__nor2_1
XFILLER_22_27 VGND VGND VPWR VPWR sky130_fd_sc_hd__fill_1
Xfanout133 net3 VGND VGND VPWR VPWR net133 sky130_fd_sc_hd__buf_1
Xfanout144 net146 VGND VGND VPWR VPWR net144 sky130_fd_sc_hd__buf_2
Xfanout177 net16 VGND VGND VPWR VPWR net177 sky130_fd_sc_hd__buf_1
Xfanout155 net156 VGND VGND VPWR VPWR net155 sky130_fd_sc_hd__buf_2
Xfanout100 net104 VGND VGND VPWR VPWR net100 sky130_fd_sc_hd__buf_2
Xfanout188 net10 VGND VGND VPWR VPWR net188 sky130_fd_sc_hd__buf_2
Xfanout122 net126 VGND VGND VPWR VPWR net122 sky130_fd_sc_hd__buf_1
Xfanout111 net116 VGND VGND VPWR VPWR net111 sky130_fd_sc_hd__clkbuf_4
Xfanout166 net167 VGND VGND VPWR VPWR net166 sky130_fd_sc_hd__clkbuf_2
XFILLER_47_57 VPWR VGND VPWR VGND sky130_ef_sc_hd__decap_12
XPHY_EDGE_ROW_29_Right_29 VGND VGND VPWR VPWR sky130_fd_sc_hd__decap_3
XFILLER_27_231 VGND VGND VPWR VPWR sky130_fd_sc_hd__fill_1
XPHY_EDGE_ROW_38_Right_38 VGND VGND VPWR VPWR sky130_fd_sc_hd__decap_3
XFILLER_8_29 VGND VGND VPWR VPWR sky130_fd_sc_hd__decap_4
XFILLER_10_175 VGND VGND VPWR VPWR sky130_fd_sc_hd__fill_2
XFILLER_10_197 VGND VGND VPWR VPWR sky130_fd_sc_hd__fill_2
XPHY_EDGE_ROW_47_Right_47 VGND VGND VPWR VPWR sky130_fd_sc_hd__decap_3
X_1962_ net162 net155 net158 net132 VGND VGND VPWR VPWR _1101_ sky130_fd_sc_hd__and4_1
XFILLER_33_278 VGND VGND VPWR VPWR sky130_fd_sc_hd__fill_2
XFILLER_33_234 VGND VGND VPWR VPWR sky130_fd_sc_hd__decap_4
X_1893_ _1028_ _1030_ _0992_ _1027_ VGND VGND VPWR VPWR _1032_ sky130_fd_sc_hd__o211a_1
XTAP_TAPCELL_ROW_11_170 VGND VPWR sky130_fd_sc_hd__tapvpwrvgnd_1
X_2376_ clknet_2_3__leaf_clk _0016_ net139 VGND VGND VPWR VPWR net51 sky130_fd_sc_hd__dfrtp_1
X_1327_ net173 net123 net58 VGND VGND VPWR VPWR _0466_ sky130_fd_sc_hd__a21oi_1
X_1258_ _0395_ _0396_ VGND VGND VPWR VPWR _0397_ sky130_fd_sc_hd__nand2_1
X_1189_ net148 net143 net121 VGND VGND VPWR VPWR _0328_ sky130_fd_sc_hd__and3_1
XTAP_TAPCELL_ROW_34_295 VGND VPWR sky130_fd_sc_hd__tapvpwrvgnd_1
XFILLER_30_204 VGND VGND VPWR VPWR sky130_fd_sc_hd__fill_1
X_2230_ _1046_ _1057_ _1070_ VGND VGND VPWR VPWR _0241_ sky130_fd_sc_hd__nand3_1
X_2092_ _0096_ _0106_ _0695_ _0093_ VGND VGND VPWR VPWR _0107_ sky130_fd_sc_hd__a211oi_2
XFILLER_0_41 VGND VGND VPWR VPWR sky130_fd_sc_hd__decap_8
XTAP_TAPCELL_ROW_0_108 VGND VPWR sky130_fd_sc_hd__tapvpwrvgnd_1
X_2161_ _0152_ _0155_ _0175_ VGND VGND VPWR VPWR _0176_ sky130_fd_sc_hd__o21a_1
XTAP_TAPCELL_ROW_31_276 VGND VPWR sky130_fd_sc_hd__tapvpwrvgnd_1
XFILLER_9_50 VGND VGND VPWR VPWR sky130_fd_sc_hd__decap_6
X_1945_ _1083_ VGND VGND VPWR VPWR _1084_ sky130_fd_sc_hd__inv_2
XFILLER_21_215 VGND VGND VPWR VPWR sky130_fd_sc_hd__decap_8
X_1876_ _1006_ _1013_ _1012_ VGND VGND VPWR VPWR _1015_ sky130_fd_sc_hd__a21bo_1
XTAP_TAPCELL_ROW_39_321 VGND VPWR sky130_fd_sc_hd__tapvpwrvgnd_1
XFILLER_28_15 VGND VGND VPWR VPWR sky130_fd_sc_hd__fill_1
X_2359_ net268 net111 net99 net141 VGND VGND VPWR VPWR _0055_ sky130_fd_sc_hd__a22o_1
XFILLER_12_237 VGND VGND VPWR VPWR sky130_fd_sc_hd__decap_6
XTAP_TAPCELL_ROW_45_357 VGND VPWR sky130_fd_sc_hd__tapvpwrvgnd_1
X_1730_ _0867_ _0868_ VGND VGND VPWR VPWR _0869_ sky130_fd_sc_hd__or2_1
X_1592_ net225 net178 net74 VGND VGND VPWR VPWR _0731_ sky130_fd_sc_hd__a21oi_1
XFILLER_7_263 VGND VGND VPWR VPWR sky130_fd_sc_hd__decap_3
XFILLER_11_292 VGND VGND VPWR VPWR sky130_fd_sc_hd__fill_1
X_1661_ net169 net180 _0798_ VGND VGND VPWR VPWR _0800_ sky130_fd_sc_hd__and3_1
X_2213_ _0215_ _0226_ VGND VGND VPWR VPWR _0228_ sky130_fd_sc_hd__or2_4
X_2144_ _0157_ _0158_ VGND VGND VPWR VPWR _0159_ sky130_fd_sc_hd__nor2_1
XFILLER_38_167 VPWR VGND VPWR VGND sky130_ef_sc_hd__decap_12
X_2075_ _0086_ _0088_ _0089_ VGND VGND VPWR VPWR _0090_ sky130_fd_sc_hd__o21a_1
XFILLER_30_38 VGND VGND VPWR VPWR sky130_fd_sc_hd__decap_6
XFILLER_30_27 VGND VGND VPWR VPWR sky130_fd_sc_hd__fill_1
X_1928_ _1052_ _1065_ _1066_ VGND VGND VPWR VPWR _1067_ sky130_fd_sc_hd__and3_1
X_1859_ _0996_ _0997_ net151 net191 VGND VGND VPWR VPWR _0998_ sky130_fd_sc_hd__and4bb_1
XFILLER_29_167 VGND VGND VPWR VPWR sky130_fd_sc_hd__fill_1
XTAP_TAPCELL_ROW_42_338 VGND VPWR sky130_fd_sc_hd__tapvpwrvgnd_1
Xhold80 net54 VGND VGND VPWR VPWR net271 sky130_fd_sc_hd__dlygate4sd3_1
Xhold91 net61 VGND VGND VPWR VPWR net282 sky130_fd_sc_hd__dlygate4sd3_1
X_1713_ _0848_ _0849_ net166 net132 VGND VGND VPWR VPWR _0852_ sky130_fd_sc_hd__a2bb2o_1
X_1644_ _0779_ _0780_ net166 net158 VGND VGND VPWR VPWR _0783_ sky130_fd_sc_hd__a2bb2o_1
X_1575_ _0712_ _0713_ VGND VGND VPWR VPWR _0714_ sky130_fd_sc_hd__and2b_1
X_2127_ _0141_ VGND VGND VPWR VPWR _0142_ sky130_fd_sc_hd__inv_2
Xrebuffer12 _0787_ VGND VGND VPWR VPWR net203 sky130_fd_sc_hd__buf_2
X_2058_ _0069_ _0070_ _0056_ VGND VGND VPWR VPWR _0073_ sky130_fd_sc_hd__a21oi_1
XFILLER_41_129 VGND VGND VPWR VPWR sky130_fd_sc_hd__decap_8
XFILLER_26_148 VGND VGND VPWR VPWR sky130_fd_sc_hd__decap_3
XFILLER_25_49 VGND VGND VPWR VPWR sky130_fd_sc_hd__decap_6
XFILLER_49_207 VPWR VGND VPWR VGND sky130_ef_sc_hd__decap_12
XFILLER_1_269 VGND VGND VPWR VPWR sky130_fd_sc_hd__decap_8
XFILLER_17_104 VGND VGND VPWR VPWR sky130_fd_sc_hd__decap_8
Xoutput70 net70 VGND VGND VPWR VPWR acc_out[4] sky130_fd_sc_hd__buf_2
X_1360_ _0497_ _0498_ VGND VGND VPWR VPWR _0499_ sky130_fd_sc_hd__or2_1
XFILLER_48_251 VGND VGND VPWR VPWR sky130_fd_sc_hd__fill_1
Xoutput81 net81 VGND VGND VPWR VPWR b_out[5] sky130_fd_sc_hd__buf_2
X_1291_ _0429_ _0410_ VGND VGND VPWR VPWR _0430_ sky130_fd_sc_hd__and2b_1
XFILLER_16_192 VGND VGND VPWR VPWR sky130_fd_sc_hd__fill_1
XFILLER_31_173 VGND VGND VPWR VPWR sky130_fd_sc_hd__fill_1
XFILLER_31_162 VGND VGND VPWR VPWR sky130_fd_sc_hd__decap_6
XFILLER_11_18 VPWR VGND VPWR VGND sky130_ef_sc_hd__decap_12
X_1558_ _0686_ _0692_ _0685_ VGND VGND VPWR VPWR _0697_ sky130_fd_sc_hd__a21boi_1
X_1627_ _0764_ _0765_ VGND VGND VPWR VPWR _0766_ sky130_fd_sc_hd__nor2_1
X_1489_ _0588_ _0627_ VGND VGND VPWR VPWR _0628_ sky130_fd_sc_hd__nand2_1
XFILLER_36_26 VGND VGND VPWR VPWR sky130_fd_sc_hd__fill_2
XFILLER_6_317 VGND VGND VPWR VPWR sky130_fd_sc_hd__decap_3
XFILLER_7_3 VPWR VGND VPWR VGND sky130_ef_sc_hd__decap_12
XTAP_TAPCELL_ROW_9_155 VGND VPWR sky130_fd_sc_hd__tapvpwrvgnd_1
XFILLER_13_151 VPWR VGND VPWR VGND sky130_ef_sc_hd__decap_12
Xrebuffer3 net193 VGND VGND VPWR VPWR net194 sky130_fd_sc_hd__buf_1
X_1343_ _0472_ _0478_ _0480_ VGND VGND VPWR VPWR _0482_ sky130_fd_sc_hd__nor3_1
X_2392_ clknet_2_2__leaf_clk _0032_ net137 VGND VGND VPWR VPWR net28 sky130_fd_sc_hd__dfrtp_1
X_1412_ net92 _0549_ VGND VGND VPWR VPWR _0551_ sky130_fd_sc_hd__xor2_1
XFILLER_36_265 VGND VGND VPWR VPWR sky130_fd_sc_hd__fill_1
X_1274_ _0375_ _0376_ net109 VGND VGND VPWR VPWR _0413_ sky130_fd_sc_hd__o21a_1
XFILLER_47_69 VPWR VGND VPWR VGND sky130_ef_sc_hd__decap_12
Xfanout156 net157 VGND VGND VPWR VPWR net156 sky130_fd_sc_hd__clkbuf_4
Xfanout178 net15 VGND VGND VPWR VPWR net178 sky130_fd_sc_hd__clkbuf_2
Xfanout145 net146 VGND VGND VPWR VPWR net145 sky130_fd_sc_hd__buf_2
Xfanout112 net116 VGND VGND VPWR VPWR net112 sky130_fd_sc_hd__buf_2
Xfanout134 net135 VGND VGND VPWR VPWR net134 sky130_fd_sc_hd__clkbuf_4
Xfanout189 net10 VGND VGND VPWR VPWR net189 sky130_fd_sc_hd__buf_1
Xfanout101 net102 VGND VGND VPWR VPWR net101 sky130_fd_sc_hd__buf_2
Xfanout167 net18 VGND VGND VPWR VPWR net167 sky130_fd_sc_hd__buf_6
Xfanout123 net126 VGND VGND VPWR VPWR net123 sky130_fd_sc_hd__clkbuf_2
XFILLER_27_265 VGND VGND VPWR VPWR sky130_fd_sc_hd__decap_6
XFILLER_27_221 VGND VGND VPWR VPWR sky130_fd_sc_hd__decap_3
XFILLER_37_91 VGND VGND VPWR VPWR sky130_fd_sc_hd__decap_6
X_1961_ _1097_ _1098_ VGND VGND VPWR VPWR _1100_ sky130_fd_sc_hd__xnor2_1
XTAP_TAPCELL_ROW_28_260 VGND VPWR sky130_fd_sc_hd__tapvpwrvgnd_1
X_1892_ _1030_ VGND VGND VPWR VPWR _1031_ sky130_fd_sc_hd__inv_2
XFILLER_5_191 VGND VGND VPWR VPWR sky130_fd_sc_hd__decap_8
XFILLER_5_180 VGND VGND VPWR VPWR sky130_fd_sc_hd__decap_3
X_2375_ clknet_2_1__leaf_clk _0015_ net136 VGND VGND VPWR VPWR net50 sky130_fd_sc_hd__dfrtp_1
X_1326_ net173 net123 net58 VGND VGND VPWR VPWR _0465_ sky130_fd_sc_hd__and3_1
XFILLER_24_246 VGND VGND VPWR VPWR sky130_fd_sc_hd__decap_6
X_1257_ _0345_ _0348_ _0391_ _0394_ VGND VGND VPWR VPWR _0396_ sky130_fd_sc_hd__o22ai_1
X_1188_ net26 net25 VGND VGND VPWR VPWR _0327_ sky130_fd_sc_hd__nor2_1
XTAP_TAPCELL_ROW_34_296 VGND VPWR sky130_fd_sc_hd__tapvpwrvgnd_1
XFILLER_47_305 VPWR VGND VPWR VGND sky130_ef_sc_hd__decap_12
XPHY_EDGE_ROW_29_Left_79 VGND VGND VPWR VPWR sky130_fd_sc_hd__decap_3
X_2160_ _0340_ _0169_ VGND VGND VPWR VPWR _0175_ sky130_fd_sc_hd__xnor2_1
X_2091_ _0096_ _0103_ _0104_ VGND VGND VPWR VPWR _0106_ sky130_fd_sc_hd__nand3_1
XFILLER_0_20 VGND VGND VPWR VPWR sky130_fd_sc_hd__decap_8
XTAP_TAPCELL_ROW_0_109 VGND VPWR sky130_fd_sc_hd__tapvpwrvgnd_1
XTAP_TAPCELL_ROW_31_277 VGND VPWR sky130_fd_sc_hd__tapvpwrvgnd_1
X_1875_ _1006_ _1012_ _1013_ VGND VGND VPWR VPWR _1014_ sky130_fd_sc_hd__nand3_1
X_1944_ _1024_ _1082_ _1080_ VGND VGND VPWR VPWR _1083_ sky130_fd_sc_hd__nor3_4
XTAP_TAPCELL_ROW_39_322 VGND VPWR sky130_fd_sc_hd__tapvpwrvgnd_1
X_2289_ _0138_ _0142_ VGND VGND VPWR VPWR _0284_ sky130_fd_sc_hd__nand2_1
X_2358_ net258 net110 net98 net146 VGND VGND VPWR VPWR _0054_ sky130_fd_sc_hd__a22o_1
X_1309_ _0446_ _0447_ VGND VGND VPWR VPWR _0448_ sky130_fd_sc_hd__or2_1
XFILLER_44_26 VGND VGND VPWR VPWR sky130_fd_sc_hd__fill_2
XFILLER_47_113 VGND VGND VPWR VPWR sky130_fd_sc_hd__decap_6
XFILLER_35_308 VGND VGND VPWR VPWR sky130_fd_sc_hd__fill_1
XFILLER_34_92 VGND VGND VPWR VPWR sky130_fd_sc_hd__fill_1
XFILLER_7_286 VGND VGND VPWR VPWR sky130_fd_sc_hd__decap_8
X_1660_ net168 net180 VGND VGND VPWR VPWR _0799_ sky130_fd_sc_hd__nand2_1
X_1591_ net170 net178 net74 VGND VGND VPWR VPWR _0730_ sky130_fd_sc_hd__and3_4
XFILLER_38_179 VGND VGND VPWR VPWR sky130_fd_sc_hd__decap_4
XFILLER_38_113 VGND VGND VPWR VPWR sky130_fd_sc_hd__decap_3
XFILLER_26_319 VGND VGND VPWR VPWR sky130_fd_sc_hd__fill_1
X_2212_ _0214_ _0215_ _0226_ VGND VGND VPWR VPWR _0227_ sky130_fd_sc_hd__and3_4
X_2143_ _0542_ _0545_ _0156_ VGND VGND VPWR VPWR _0158_ sky130_fd_sc_hd__nor3_1
XTAP_TAPCELL_ROW_36_303 VGND VPWR sky130_fd_sc_hd__tapvpwrvgnd_1
X_2074_ _1168_ _0083_ _0080_ VGND VGND VPWR VPWR _0089_ sky130_fd_sc_hd__a21o_1
XFILLER_14_18 VGND VGND VPWR VPWR sky130_fd_sc_hd__decap_8
XFILLER_14_29 VGND VGND VPWR VPWR sky130_fd_sc_hd__decap_6
X_1927_ _1049_ _1050_ net165 net190 VGND VGND VPWR VPWR _1066_ sky130_fd_sc_hd__a2bb2o_1
X_1858_ net157 net119 net118 net160 VGND VGND VPWR VPWR _0997_ sky130_fd_sc_hd__a22oi_1
X_1789_ _0901_ _0914_ _0926_ _0927_ VGND VGND VPWR VPWR _0928_ sky130_fd_sc_hd__o211a_1
XFILLER_29_179 VGND VGND VPWR VPWR sky130_fd_sc_hd__decap_8
XTAP_TAPCELL_ROW_42_339 VGND VPWR sky130_fd_sc_hd__tapvpwrvgnd_1
Xhold81 net59 VGND VGND VPWR VPWR net272 sky130_fd_sc_hd__dlygate4sd3_1
Xhold92 net62 VGND VGND VPWR VPWR net283 sky130_fd_sc_hd__dlygate4sd3_1
Xhold70 net79 VGND VGND VPWR VPWR net261 sky130_fd_sc_hd__dlygate4sd3_1
XFILLER_35_149 VGND VGND VPWR VPWR sky130_fd_sc_hd__decap_8
XFILLER_35_127 VPWR VGND VPWR VGND sky130_ef_sc_hd__decap_12
X_1712_ _0319_ _0325_ _0848_ _0849_ VGND VGND VPWR VPWR _0851_ sky130_fd_sc_hd__or4_1
X_1643_ _0319_ _0324_ _0779_ _0780_ VGND VGND VPWR VPWR _0782_ sky130_fd_sc_hd__or4_4
XANTENNA_1 net19 VGND VGND VPWR VPWR sky130_fd_sc_hd__diode_2
X_1574_ net155 net182 net180 net162 VGND VGND VPWR VPWR _0713_ sky130_fd_sc_hd__a22o_1
XFILLER_6_85 VGND VGND VPWR VPWR sky130_fd_sc_hd__fill_1
X_2057_ _0056_ _0069_ _0070_ VGND VGND VPWR VPWR _0072_ sky130_fd_sc_hd__nand3_1
X_2126_ _0124_ _0139_ _0140_ VGND VGND VPWR VPWR _0141_ sky130_fd_sc_hd__o21ai_1
Xrebuffer35 _0785_ VGND VGND VPWR VPWR net226 sky130_fd_sc_hd__dlygate4sd1_1
Xrebuffer13 _0755_ VGND VGND VPWR VPWR net204 sky130_fd_sc_hd__buf_1
XPHY_EDGE_ROW_16_Left_66 VGND VGND VPWR VPWR sky130_fd_sc_hd__decap_3
XFILLER_49_219 VGND VGND VPWR VPWR sky130_fd_sc_hd__decap_4
XFILLER_40_152 VGND VGND VPWR VPWR sky130_fd_sc_hd__decap_4
XFILLER_9_304 VGND VGND VPWR VPWR sky130_fd_sc_hd__decap_6
Xoutput82 net82 VGND VGND VPWR VPWR b_out[6] sky130_fd_sc_hd__buf_2
Xoutput71 net71 VGND VGND VPWR VPWR acc_out[5] sky130_fd_sc_hd__buf_2
Xoutput60 net60 VGND VGND VPWR VPWR acc_out[24] sky130_fd_sc_hd__buf_2
XFILLER_0_281 VPWR VGND VPWR VGND sky130_ef_sc_hd__decap_12
X_1290_ net92 _0428_ _0426_ VGND VGND VPWR VPWR _0429_ sky130_fd_sc_hd__a21oi_1
XFILLER_31_152 VGND VGND VPWR VPWR sky130_fd_sc_hd__decap_3
X_1626_ net145 net185 net183 net150 VGND VGND VPWR VPWR _0765_ sky130_fd_sc_hd__a22oi_1
X_1557_ _0682_ _0695_ _0658_ _0667_ VGND VGND VPWR VPWR _0696_ sky130_fd_sc_hd__o211a_1
X_1488_ _0623_ _0625_ VGND VGND VPWR VPWR _0627_ sky130_fd_sc_hd__xor2_2
X_2109_ _0112_ _0123_ VGND VGND VPWR VPWR _0124_ sky130_fd_sc_hd__or2_1
XFILLER_39_263 VGND VGND VPWR VPWR sky130_fd_sc_hd__fill_1
XFILLER_22_130 VGND VGND VPWR VPWR sky130_fd_sc_hd__decap_4
XTAP_TAPCELL_ROW_9_156 VGND VPWR sky130_fd_sc_hd__tapvpwrvgnd_1
XFILLER_45_222 VGND VGND VPWR VPWR sky130_fd_sc_hd__fill_2
XFILLER_26_82 VGND VGND VPWR VPWR sky130_fd_sc_hd__fill_2
XFILLER_13_163 VGND VGND VPWR VPWR sky130_fd_sc_hd__decap_4
Xrebuffer4 _0876_ VGND VGND VPWR VPWR net195 sky130_fd_sc_hd__dlymetal6s2s_1
XFILLER_9_167 VGND VGND VPWR VPWR sky130_fd_sc_hd__fill_1
X_1342_ _0478_ _0480_ _0472_ VGND VGND VPWR VPWR _0481_ sky130_fd_sc_hd__o21a_1
X_1273_ net96 _0380_ VGND VGND VPWR VPWR _0412_ sky130_fd_sc_hd__xor2_1
X_2391_ clknet_2_0__leaf_clk _0031_ net138 VGND VGND VPWR VPWR net68 sky130_fd_sc_hd__dfrtp_2
X_1411_ net93 _0549_ VGND VGND VPWR VPWR _0550_ sky130_fd_sc_hd__and2_1
XFILLER_36_222 VGND VGND VPWR VPWR sky130_fd_sc_hd__fill_2
X_1609_ _0746_ _0747_ VGND VGND VPWR VPWR _0748_ sky130_fd_sc_hd__xnor2_1
Xfanout102 net103 VGND VGND VPWR VPWR net102 sky130_fd_sc_hd__buf_2
Xfanout113 net114 VGND VGND VPWR VPWR net113 sky130_fd_sc_hd__buf_2
Xfanout179 net15 VGND VGND VPWR VPWR net179 sky130_fd_sc_hd__dlymetal6s2s_1
XFILLER_47_15 VPWR VGND VPWR VGND sky130_ef_sc_hd__decap_12
Xfanout157 net20 VGND VGND VPWR VPWR net157 sky130_fd_sc_hd__buf_2
Xfanout124 net126 VGND VGND VPWR VPWR net124 sky130_fd_sc_hd__buf_1
Xfanout146 net23 VGND VGND VPWR VPWR net146 sky130_fd_sc_hd__buf_2
Xfanout135 net140 VGND VGND VPWR VPWR net135 sky130_fd_sc_hd__clkbuf_4
Xfanout168 net169 VGND VGND VPWR VPWR net168 sky130_fd_sc_hd__buf_6
XFILLER_10_122 VGND VGND VPWR VPWR sky130_fd_sc_hd__fill_2
XFILLER_33_225 VGND VGND VPWR VPWR sky130_fd_sc_hd__fill_2
XFILLER_33_203 VGND VGND VPWR VPWR sky130_fd_sc_hd__decap_3
XTAP_TAPCELL_ROW_28_261 VGND VPWR sky130_fd_sc_hd__tapvpwrvgnd_1
XFILLER_18_288 VGND VGND VPWR VPWR sky130_fd_sc_hd__fill_1
X_1960_ _1098_ VGND VGND VPWR VPWR _1099_ sky130_fd_sc_hd__inv_2
X_1891_ _1028_ _1029_ net164 net119 VGND VGND VPWR VPWR _1030_ sky130_fd_sc_hd__and4bb_1
X_2374_ clknet_2_1__leaf_clk _0014_ net136 VGND VGND VPWR VPWR net49 sky130_fd_sc_hd__dfrtp_1
X_1325_ net106 _0463_ VGND VGND VPWR VPWR _0464_ sky130_fd_sc_hd__xnor2_1
X_1256_ _0345_ _0348_ _0391_ _0394_ VGND VGND VPWR VPWR _0395_ sky130_fd_sc_hd__or4_1
X_1187_ net121 VGND VGND VPWR VPWR _0326_ sky130_fd_sc_hd__inv_2
XTAP_TAPCELL_ROW_34_297 VGND VPWR sky130_fd_sc_hd__tapvpwrvgnd_1
XFILLER_32_291 VGND VGND VPWR VPWR sky130_fd_sc_hd__decap_8
XFILLER_47_317 VGND VGND VPWR VPWR sky130_fd_sc_hd__decap_3
XFILLER_15_214 VGND VGND VPWR VPWR sky130_fd_sc_hd__fill_1
XFILLER_30_228 VGND VGND VPWR VPWR sky130_fd_sc_hd__decap_3
XPHY_EDGE_ROW_4_Left_54 VGND VGND VPWR VPWR sky130_fd_sc_hd__decap_3
XFILLER_15_269 VGND VGND VPWR VPWR sky130_fd_sc_hd__fill_1
XFILLER_48_91 VGND VGND VPWR VPWR sky130_fd_sc_hd__fill_1
X_2090_ _0096_ _0103_ _0104_ VGND VGND VPWR VPWR _0105_ sky130_fd_sc_hd__and3_1
XFILLER_38_317 VGND VGND VPWR VPWR sky130_fd_sc_hd__decap_3
XFILLER_2_195 VGND VGND VPWR VPWR sky130_fd_sc_hd__fill_1
XTAP_TAPCELL_ROW_31_278 VGND VPWR sky130_fd_sc_hd__tapvpwrvgnd_1
X_1874_ _1011_ _0977_ _1009_ net194 VGND VGND VPWR VPWR _1013_ sky130_fd_sc_hd__a211o_1
X_1943_ _0988_ _1020_ VGND VGND VPWR VPWR _1082_ sky130_fd_sc_hd__xnor2_1
XPHY_EDGE_ROW_46_Left_96 VGND VGND VPWR VPWR sky130_fd_sc_hd__decap_3
XFILLER_44_309 VGND VGND VPWR VPWR sky130_fd_sc_hd__decap_8
XTAP_TAPCELL_ROW_39_323 VGND VPWR sky130_fd_sc_hd__tapvpwrvgnd_1
X_2288_ net271 net115 net103 _0283_ VGND VGND VPWR VPWR _0019_ sky130_fd_sc_hd__a22o_1
X_2357_ net265 net113 net101 net148 VGND VGND VPWR VPWR _0053_ sky130_fd_sc_hd__a22o_1
X_1239_ _0375_ _0377_ VGND VGND VPWR VPWR _0378_ sky130_fd_sc_hd__or2_1
X_1308_ _0436_ _0443_ _0445_ VGND VGND VPWR VPWR _0447_ sky130_fd_sc_hd__nor3_1
XFILLER_12_217 VGND VGND VPWR VPWR sky130_fd_sc_hd__decap_4
XFILLER_47_169 VGND VGND VPWR VPWR sky130_fd_sc_hd__fill_1
X_1590_ _0728_ _0723_ VGND VGND VPWR VPWR _0729_ sky130_fd_sc_hd__and2b_1
XFILLER_38_158 VGND VGND VPWR VPWR sky130_fd_sc_hd__fill_1
XTAP_TAPCELL_ROW_36_304 VGND VPWR sky130_fd_sc_hd__tapvpwrvgnd_1
X_2073_ _0870_ _1128_ _1127_ VGND VGND VPWR VPWR _0088_ sky130_fd_sc_hd__a21oi_1
XFILLER_26_309 VGND VGND VPWR VPWR sky130_fd_sc_hd__fill_2
XFILLER_15_3 VGND VGND VPWR VPWR sky130_fd_sc_hd__fill_1
X_2211_ _0407_ _0408_ _0430_ _0225_ VGND VGND VPWR VPWR _0226_ sky130_fd_sc_hd__a31o_1
X_2142_ _0542_ _0545_ _0156_ VGND VGND VPWR VPWR _0157_ sky130_fd_sc_hd__o21a_1
XFILLER_30_29 VGND VGND VPWR VPWR sky130_fd_sc_hd__fill_2
X_1926_ net169 net190 net44 VGND VGND VPWR VPWR _1065_ sky130_fd_sc_hd__and3_1
X_1857_ net160 net157 net119 net118 VGND VGND VPWR VPWR _0996_ sky130_fd_sc_hd__and4_1
X_1788_ _0924_ _0925_ _0921_ VGND VGND VPWR VPWR _0927_ sky130_fd_sc_hd__a21o_1
XFILLER_39_49 VGND VGND VPWR VPWR sky130_fd_sc_hd__fill_2
XFILLER_39_38 VGND VGND VPWR VPWR sky130_fd_sc_hd__fill_1
X_2409_ clknet_2_2__leaf_clk _0049_ net137 VGND VGND VPWR VPWR net77 sky130_fd_sc_hd__dfrtp_1
Xhold71 net43 VGND VGND VPWR VPWR net262 sky130_fd_sc_hd__dlygate4sd3_1
Xhold93 net53 VGND VGND VPWR VPWR net284 sky130_fd_sc_hd__dlygate4sd3_1
Xhold82 net65 VGND VGND VPWR VPWR net273 sky130_fd_sc_hd__dlygate4sd3_1
Xhold60 net76 VGND VGND VPWR VPWR net251 sky130_fd_sc_hd__dlygate4sd3_1
XFILLER_35_139 VGND VGND VPWR VPWR sky130_fd_sc_hd__decap_6
X_1711_ _0848_ _0849_ net166 net132 VGND VGND VPWR VPWR _0850_ sky130_fd_sc_hd__and4bb_1
X_1642_ _0779_ _0780_ net166 net158 VGND VGND VPWR VPWR _0781_ sky130_fd_sc_hd__and4bb_1
XANTENNA_2 net21 VGND VGND VPWR VPWR sky130_fd_sc_hd__diode_2
X_1573_ net162 net155 net182 net180 VGND VGND VPWR VPWR _0712_ sky130_fd_sc_hd__and4_1
X_2125_ _0111_ _0122_ _0091_ VGND VGND VPWR VPWR _0140_ sky130_fd_sc_hd__a21o_1
X_2056_ _0056_ _0069_ _0070_ VGND VGND VPWR VPWR _0071_ sky130_fd_sc_hd__and3_1
XFILLER_41_109 VGND VGND VPWR VPWR sky130_fd_sc_hd__decap_3
Xrebuffer14 _0526_ VGND VGND VPWR VPWR net205 sky130_fd_sc_hd__dlygate4sd1_1
XFILLER_25_29 VGND VGND VPWR VPWR sky130_fd_sc_hd__fill_1
X_1909_ _1028_ _1029_ net164 net120 VGND VGND VPWR VPWR _1048_ sky130_fd_sc_hd__a2bb2o_1
XFILLER_25_150 VGND VGND VPWR VPWR sky130_fd_sc_hd__decap_3
XFILLER_17_139 VGND VGND VPWR VPWR sky130_fd_sc_hd__fill_1
XFILLER_40_164 VGND VGND VPWR VPWR sky130_fd_sc_hd__decap_4
XPHY_EDGE_ROW_33_Left_83 VGND VGND VPWR VPWR sky130_fd_sc_hd__decap_3
XFILLER_31_94 VGND VGND VPWR VPWR sky130_fd_sc_hd__fill_1
XFILLER_31_50 VGND VGND VPWR VPWR sky130_fd_sc_hd__fill_2
Xoutput50 net50 VGND VGND VPWR VPWR acc_out[15] sky130_fd_sc_hd__buf_2
Xoutput83 net83 VGND VGND VPWR VPWR b_out[7] sky130_fd_sc_hd__buf_2
Xoutput72 net72 VGND VGND VPWR VPWR acc_out[6] sky130_fd_sc_hd__buf_2
Xoutput61 net61 VGND VGND VPWR VPWR acc_out[25] sky130_fd_sc_hd__buf_2
XFILLER_48_253 VPWR VGND VPWR VGND sky130_ef_sc_hd__decap_12
XFILLER_0_293 VPWR VGND VPWR VGND sky130_ef_sc_hd__decap_12
X_1556_ _0682_ _0694_ _0693_ VGND VGND VPWR VPWR _0695_ sky130_fd_sc_hd__nor3b_2
X_1625_ net150 net145 net185 net183 VGND VGND VPWR VPWR _0764_ sky130_fd_sc_hd__and4_1
X_1487_ _0623_ _0625_ VGND VGND VPWR VPWR _0626_ sky130_fd_sc_hd__nand2_1
X_2108_ _0120_ _0121_ VGND VGND VPWR VPWR _0123_ sky130_fd_sc_hd__xnor2_1
X_2039_ _1133_ _1135_ _1134_ VGND VGND VPWR VPWR _1178_ sky130_fd_sc_hd__o21ba_1
XTAP_TAPCELL_ROW_9_157 VGND VPWR sky130_fd_sc_hd__tapvpwrvgnd_1
XFILLER_45_278 VGND VGND VPWR VPWR sky130_fd_sc_hd__fill_2
XFILLER_42_71 VPWR VGND VPWR VGND sky130_ef_sc_hd__decap_12
XFILLER_13_197 VPWR VGND VPWR VGND sky130_ef_sc_hd__decap_12
Xrebuffer5 net195 VGND VGND VPWR VPWR net196 sky130_fd_sc_hd__dlymetal6s2s_1
X_1410_ _0547_ _0548_ VGND VGND VPWR VPWR _0549_ sky130_fd_sc_hd__nor2_1
X_1341_ _0342_ _0479_ VGND VGND VPWR VPWR _0480_ sky130_fd_sc_hd__and2_1
X_1272_ _0340_ _0384_ VGND VGND VPWR VPWR _0411_ sky130_fd_sc_hd__xnor2_1
X_2390_ clknet_2_2__leaf_clk _0030_ net138 VGND VGND VPWR VPWR net67 sky130_fd_sc_hd__dfrtp_1
X_1539_ _0676_ _0677_ VGND VGND VPWR VPWR _0678_ sky130_fd_sc_hd__xnor2_1
X_1608_ net152 net182 VGND VGND VPWR VPWR _0747_ sky130_fd_sc_hd__nand2_1
Xfanout125 net126 VGND VGND VPWR VPWR net125 sky130_fd_sc_hd__buf_2
Xfanout136 net140 VGND VGND VPWR VPWR net136 sky130_fd_sc_hd__clkbuf_4
XTAP_TAPCELL_ROW_6_138 VGND VPWR sky130_fd_sc_hd__tapvpwrvgnd_1
Xfanout103 net104 VGND VGND VPWR VPWR net103 sky130_fd_sc_hd__clkbuf_4
Xfanout114 net115 VGND VGND VPWR VPWR net114 sky130_fd_sc_hd__buf_2
Xfanout147 net22 VGND VGND VPWR VPWR net147 sky130_fd_sc_hd__buf_2
XFILLER_47_27 VPWR VGND VPWR VGND sky130_ef_sc_hd__decap_12
Xfanout158 net2 VGND VGND VPWR VPWR net158 sky130_fd_sc_hd__buf_2
XFILLER_27_256 VGND VGND VPWR VPWR sky130_fd_sc_hd__decap_4
Xfanout169 net175 VGND VGND VPWR VPWR net169 sky130_fd_sc_hd__buf_8
XFILLER_42_259 VGND VGND VPWR VPWR sky130_fd_sc_hd__decap_4
XFILLER_6_105 VGND VGND VPWR VPWR sky130_fd_sc_hd__decap_8
XFILLER_6_116 VGND VGND VPWR VPWR sky130_fd_sc_hd__decap_3
XFILLER_12_52 VPWR VGND VPWR VGND sky130_ef_sc_hd__decap_12
XTAP_TAPCELL_ROW_28_262 VGND VPWR sky130_fd_sc_hd__tapvpwrvgnd_1
XPHY_EDGE_ROW_16_Right_16 VGND VGND VPWR VPWR sky130_fd_sc_hd__decap_3
XFILLER_18_234 VGND VGND VPWR VPWR sky130_fd_sc_hd__decap_4
XFILLER_41_281 VGND VGND VPWR VPWR sky130_fd_sc_hd__decap_4
XPHY_EDGE_ROW_25_Right_25 VGND VGND VPWR VPWR sky130_fd_sc_hd__decap_3
X_1890_ net168 net118 net66 VGND VGND VPWR VPWR _1029_ sky130_fd_sc_hd__a21oi_1
X_2373_ clknet_2_1__leaf_clk _0013_ net136 VGND VGND VPWR VPWR net48 sky130_fd_sc_hd__dfrtp_1
X_1186_ net132 VGND VGND VPWR VPWR _0325_ sky130_fd_sc_hd__inv_2
XPHY_EDGE_ROW_34_Right_34 VGND VGND VPWR VPWR sky130_fd_sc_hd__decap_3
X_1324_ _0461_ _0462_ VGND VGND VPWR VPWR _0463_ sky130_fd_sc_hd__nor2_1
X_1255_ net68 _0344_ _0392_ _0393_ VGND VGND VPWR VPWR _0394_ sky130_fd_sc_hd__a211oi_1
XFILLER_24_204 VGND VGND VPWR VPWR sky130_fd_sc_hd__decap_3
XPHY_EDGE_ROW_20_Left_70 VGND VGND VPWR VPWR sky130_fd_sc_hd__decap_3
XPHY_EDGE_ROW_43_Right_43 VGND VGND VPWR VPWR sky130_fd_sc_hd__decap_3
XTAP_TAPCELL_ROW_25_243 VGND VPWR sky130_fd_sc_hd__tapvpwrvgnd_1
XFILLER_23_281 VPWR VGND VPWR VGND sky130_ef_sc_hd__decap_12
XFILLER_2_141 VGND VGND VPWR VPWR sky130_fd_sc_hd__fill_2
XFILLER_2_185 VGND VGND VPWR VPWR sky130_fd_sc_hd__decap_3
X_1942_ _1024_ _1080_ VGND VGND VPWR VPWR _1081_ sky130_fd_sc_hd__or2_1
XTAP_TAPCELL_ROW_31_279 VGND VPWR sky130_fd_sc_hd__tapvpwrvgnd_1
X_1873_ net193 _1009_ _1011_ _0977_ VGND VGND VPWR VPWR _1012_ sky130_fd_sc_hd__o211ai_2
X_2356_ net264 net113 net101 net21 VGND VGND VPWR VPWR _0052_ sky130_fd_sc_hd__a22o_1
XTAP_TAPCELL_ROW_39_324 VGND VPWR sky130_fd_sc_hd__tapvpwrvgnd_1
X_2287_ net87 _0282_ net91 VGND VGND VPWR VPWR _0283_ sky130_fd_sc_hd__a21o_1
X_1238_ net109 _0375_ _0376_ VGND VGND VPWR VPWR _0377_ sky130_fd_sc_hd__nor3_1
X_1307_ _0443_ _0445_ _0436_ VGND VGND VPWR VPWR _0446_ sky130_fd_sc_hd__o21a_1
XFILLER_34_50 VPWR VGND VPWR VGND sky130_ef_sc_hd__decap_12
XFILLER_7_222 VGND VGND VPWR VPWR sky130_fd_sc_hd__fill_2
X_2210_ _0407_ _0224_ VGND VGND VPWR VPWR _0225_ sky130_fd_sc_hd__xnor2_1
XFILLER_46_170 VGND VGND VPWR VPWR sky130_fd_sc_hd__fill_1
XFILLER_38_137 VGND VGND VPWR VPWR sky130_fd_sc_hd__decap_3
XTAP_TAPCELL_ROW_36_305 VGND VPWR sky130_fd_sc_hd__tapvpwrvgnd_1
X_2072_ _1130_ _1088_ _0086_ _0872_ VGND VGND VPWR VPWR _0087_ sky130_fd_sc_hd__or4b_4
X_2141_ _0340_ _0154_ VGND VGND VPWR VPWR _0156_ sky130_fd_sc_hd__xnor2_1
X_1925_ _1056_ _1063_ VGND VGND VPWR VPWR _1064_ sky130_fd_sc_hd__nor2_1
X_1856_ _0958_ _0993_ _0991_ _0989_ VGND VGND VPWR VPWR _0995_ sky130_fd_sc_hd__a211o_1
X_1787_ _0921_ _0924_ _0925_ VGND VGND VPWR VPWR _0926_ sky130_fd_sc_hd__nand3_2
XFILLER_29_148 VGND VGND VPWR VPWR sky130_fd_sc_hd__fill_2
XFILLER_29_126 VGND VGND VPWR VPWR sky130_fd_sc_hd__fill_1
XPHY_EDGE_ROW_2_Right_2 VGND VGND VPWR VPWR sky130_fd_sc_hd__decap_3
X_2339_ net247 net110 net98 net188 VGND VGND VPWR VPWR _0035_ sky130_fd_sc_hd__a22o_1
X_2408_ clknet_2_2__leaf_clk _0048_ net138 VGND VGND VPWR VPWR net76 sky130_fd_sc_hd__dfrtp_1
XFILLER_20_41 VGND VGND VPWR VPWR sky130_fd_sc_hd__decap_4
Xhold83 net58 VGND VGND VPWR VPWR net274 sky130_fd_sc_hd__dlygate4sd3_1
Xhold72 net36 VGND VGND VPWR VPWR net263 sky130_fd_sc_hd__dlygate4sd3_1
Xhold94 net69 VGND VGND VPWR VPWR net285 sky130_fd_sc_hd__dlygate4sd3_1
Xhold61 net40 VGND VGND VPWR VPWR net252 sky130_fd_sc_hd__dlygate4sd3_1
XFILLER_43_151 VGND VGND VPWR VPWR sky130_fd_sc_hd__decap_8
X_1641_ net224 net132 net46 VGND VGND VPWR VPWR _0780_ sky130_fd_sc_hd__a21oi_1
X_1710_ net225 net130 net47 VGND VGND VPWR VPWR _0849_ sky130_fd_sc_hd__a21oi_1
X_1572_ _0664_ _0702_ _0706_ VGND VGND VPWR VPWR _0711_ sky130_fd_sc_hd__o21ai_1
XFILLER_6_98 VGND VGND VPWR VPWR sky130_fd_sc_hd__fill_2
XFILLER_6_76 VGND VGND VPWR VPWR sky130_fd_sc_hd__decap_8
XANTENNA_3 net146 VGND VGND VPWR VPWR sky130_fd_sc_hd__diode_2
X_2124_ _0131_ _0134_ _0130_ VGND VGND VPWR VPWR _0139_ sky130_fd_sc_hd__a21boi_1
X_2055_ _0066_ _0067_ _0068_ VGND VGND VPWR VPWR _0070_ sky130_fd_sc_hd__a21o_1
Xrebuffer15 _0789_ VGND VGND VPWR VPWR net206 sky130_fd_sc_hd__dlygate4sd1_1
Xrebuffer26 _0752_ VGND VGND VPWR VPWR net217 sky130_fd_sc_hd__dlymetal6s2s_1
XFILLER_34_195 VGND VGND VPWR VPWR sky130_fd_sc_hd__fill_1
X_1908_ _1035_ _1037_ VGND VGND VPWR VPWR _1047_ sky130_fd_sc_hd__xnor2_1
X_1839_ _0971_ _0976_ _0970_ VGND VGND VPWR VPWR _0978_ sky130_fd_sc_hd__a21bo_1
XFILLER_40_121 VGND VGND VPWR VPWR sky130_fd_sc_hd__fill_2
XFILLER_25_173 VGND VGND VPWR VPWR sky130_fd_sc_hd__decap_4
Xoutput51 net51 VGND VGND VPWR VPWR acc_out[16] sky130_fd_sc_hd__buf_2
XFILLER_48_221 VPWR VGND VPWR VGND sky130_ef_sc_hd__decap_12
Xoutput62 net62 VGND VGND VPWR VPWR acc_out[26] sky130_fd_sc_hd__buf_2
Xoutput40 net40 VGND VGND VPWR VPWR a_out[6] sky130_fd_sc_hd__buf_2
Xoutput73 net73 VGND VGND VPWR VPWR acc_out[7] sky130_fd_sc_hd__buf_2
XFILLER_48_265 VPWR VGND VPWR VGND sky130_ef_sc_hd__decap_12
XFILLER_31_198 VGND VGND VPWR VPWR sky130_fd_sc_hd__fill_1
X_1555_ _0643_ _0668_ _0681_ VGND VGND VPWR VPWR _0694_ sky130_fd_sc_hd__a21oi_1
X_1624_ net142 _0322_ VGND VGND VPWR VPWR _0763_ sky130_fd_sc_hd__nand2_1
X_2107_ _0120_ _0121_ VGND VGND VPWR VPWR _0122_ sky130_fd_sc_hd__or2_1
XFILLER_39_243 VGND VGND VPWR VPWR sky130_fd_sc_hd__decap_3
X_1486_ _0587_ _0624_ VGND VGND VPWR VPWR _0625_ sky130_fd_sc_hd__and2_1
X_2038_ _1170_ _1175_ VGND VGND VPWR VPWR _1177_ sky130_fd_sc_hd__xnor2_1
XFILLER_22_110 VGND VGND VPWR VPWR sky130_fd_sc_hd__fill_1
XFILLER_6_309 VGND VGND VPWR VPWR sky130_fd_sc_hd__decap_8
XTAP_TAPCELL_ROW_9_158 VGND VPWR sky130_fd_sc_hd__tapvpwrvgnd_1
XFILLER_45_213 VGND VGND VPWR VPWR sky130_fd_sc_hd__decap_4
XFILLER_26_62 VGND VGND VPWR VPWR sky130_fd_sc_hd__fill_1
XFILLER_42_83 VGND VGND VPWR VPWR sky130_fd_sc_hd__fill_1
XFILLER_42_61 VGND VGND VPWR VPWR sky130_fd_sc_hd__decap_6
XFILLER_13_187 VGND VGND VPWR VPWR sky130_fd_sc_hd__fill_1
X_1340_ _0473_ _0477_ VGND VGND VPWR VPWR _0479_ sky130_fd_sc_hd__xor2_1
Xrebuffer6 _0876_ VGND VGND VPWR VPWR net197 sky130_fd_sc_hd__dlymetal6s2s_1
XFILLER_3_55 VGND VGND VPWR VPWR sky130_fd_sc_hd__fill_1
X_1271_ net92 _0389_ VGND VGND VPWR VPWR _0410_ sky130_fd_sc_hd__xor2_1
XFILLER_36_246 VGND VGND VPWR VPWR sky130_fd_sc_hd__decap_6
XTAP_TAPCELL_ROW_14_182 VGND VPWR sky130_fd_sc_hd__tapvpwrvgnd_1
Xfanout159 net2 VGND VGND VPWR VPWR net159 sky130_fd_sc_hd__buf_1
X_1538_ net153 net131 VGND VGND VPWR VPWR _0677_ sky130_fd_sc_hd__nand2_1
X_1469_ net149 net144 net130 net129 VGND VGND VPWR VPWR _0608_ sky130_fd_sc_hd__and4_1
X_1607_ _0744_ _0745_ VGND VGND VPWR VPWR _0746_ sky130_fd_sc_hd__and2b_1
XTAP_TAPCELL_ROW_6_139 VGND VPWR sky130_fd_sc_hd__tapvpwrvgnd_1
Xfanout137 net138 VGND VGND VPWR VPWR net137 sky130_fd_sc_hd__clkbuf_4
Xfanout126 net7 VGND VGND VPWR VPWR net126 sky130_fd_sc_hd__clkbuf_2
Xfanout148 net22 VGND VGND VPWR VPWR net148 sky130_fd_sc_hd__clkbuf_2
Xfanout104 _0232_ VGND VGND VPWR VPWR net104 sky130_fd_sc_hd__buf_2
Xfanout115 net116 VGND VGND VPWR VPWR net115 sky130_fd_sc_hd__clkbuf_4
XFILLER_47_39 VPWR VGND VPWR VGND sky130_ef_sc_hd__decap_12
XFILLER_27_279 VGND VGND VPWR VPWR sky130_fd_sc_hd__fill_1
XFILLER_5_3 VPWR VGND VPWR VGND sky130_ef_sc_hd__decap_12
XFILLER_2_301 VGND VGND VPWR VPWR sky130_fd_sc_hd__decap_6
XFILLER_12_64 VGND VGND VPWR VPWR sky130_fd_sc_hd__decap_4
XFILLER_41_260 VGND VGND VPWR VPWR sky130_fd_sc_hd__decap_6
XTAP_TAPCELL_ROW_28_263 VGND VPWR sky130_fd_sc_hd__tapvpwrvgnd_1
XFILLER_41_271 VGND VGND VPWR VPWR sky130_fd_sc_hd__decap_8
X_2372_ clknet_2_1__leaf_clk _0012_ net136 VGND VGND VPWR VPWR net47 sky130_fd_sc_hd__dfrtp_1
X_1323_ net173 net123 net59 VGND VGND VPWR VPWR _0462_ sky130_fd_sc_hd__a21oi_1
X_1185_ net158 VGND VGND VPWR VPWR _0324_ sky130_fd_sc_hd__inv_2
X_1254_ net165 net121 net68 _0344_ VGND VGND VPWR VPWR _0393_ sky130_fd_sc_hd__a211oi_1
XFILLER_3_109 VGND VGND VPWR VPWR sky130_fd_sc_hd__decap_3
XTAP_TAPCELL_ROW_2_120 VGND VPWR sky130_fd_sc_hd__tapvpwrvgnd_1
XFILLER_30_219 VGND VGND VPWR VPWR sky130_fd_sc_hd__fill_2
XTAP_TAPCELL_ROW_25_244 VGND VPWR sky130_fd_sc_hd__tapvpwrvgnd_1
XFILLER_23_85 VGND VGND VPWR VPWR sky130_fd_sc_hd__fill_2
XFILLER_23_293 VGND VGND VPWR VPWR sky130_fd_sc_hd__fill_2
XFILLER_2_175 VGND VGND VPWR VPWR sky130_fd_sc_hd__fill_2
XTAP_TAPCELL_ROW_48_369 VGND VPWR sky130_fd_sc_hd__tapvpwrvgnd_1
X_1872_ _0970_ _0971_ _0976_ VGND VGND VPWR VPWR _1011_ sky130_fd_sc_hd__a21o_1
X_1941_ _1078_ _1071_ _1077_ _1074_ VGND VGND VPWR VPWR _1080_ sky130_fd_sc_hd__o211a_4
XFILLER_14_260 VGND VGND VPWR VPWR sky130_fd_sc_hd__decap_8
X_2286_ _0112_ _0281_ VGND VGND VPWR VPWR _0282_ sky130_fd_sc_hd__xnor2_1
X_2355_ net261 net113 net101 net157 VGND VGND VPWR VPWR _0051_ sky130_fd_sc_hd__a22o_1
X_1306_ net95 _0444_ VGND VGND VPWR VPWR _0445_ sky130_fd_sc_hd__and2_1
XFILLER_44_29 VGND VGND VPWR VPWR sky130_fd_sc_hd__fill_1
XFILLER_44_18 VGND VGND VPWR VPWR sky130_fd_sc_hd__decap_8
X_1237_ net63 _0344_ VGND VGND VPWR VPWR _0376_ sky130_fd_sc_hd__nor2_1
XFILLER_18_85 VGND VGND VPWR VPWR sky130_fd_sc_hd__fill_2
XFILLER_34_62 VGND VGND VPWR VPWR sky130_fd_sc_hd__decap_4
XFILLER_7_201 VGND VGND VPWR VPWR sky130_fd_sc_hd__fill_1
XFILLER_7_278 VGND VGND VPWR VPWR sky130_fd_sc_hd__fill_2
X_2140_ net94 _0154_ VGND VGND VPWR VPWR _0155_ sky130_fd_sc_hd__nor2_1
XFILLER_38_149 VGND VGND VPWR VPWR sky130_fd_sc_hd__fill_2
XTAP_TAPCELL_ROW_36_306 VGND VPWR sky130_fd_sc_hd__tapvpwrvgnd_1
X_2071_ _0081_ _0085_ VGND VGND VPWR VPWR _0086_ sky130_fd_sc_hd__nand2_1
XTAP_TAPCELL_ROW_44_350 VGND VPWR sky130_fd_sc_hd__tapvpwrvgnd_1
X_1855_ _0989_ _0991_ _0993_ _0958_ VGND VGND VPWR VPWR _0994_ sky130_fd_sc_hd__o211ai_2
X_1924_ net161 net190 _1055_ VGND VGND VPWR VPWR _1063_ sky130_fd_sc_hd__a21oi_1
X_1786_ _0809_ _0922_ _0923_ VGND VGND VPWR VPWR _0925_ sky130_fd_sc_hd__a21o_1
X_2269_ _0085_ _0266_ _0083_ VGND VGND VPWR VPWR _0269_ sky130_fd_sc_hd__a21bo_1
X_2338_ net263 net110 net98 net118 VGND VGND VPWR VPWR _0034_ sky130_fd_sc_hd__a22o_1
X_2407_ clknet_2_3__leaf_clk _0047_ net138 VGND VGND VPWR VPWR net34 sky130_fd_sc_hd__dfrtp_1
XFILLER_29_51 VGND VGND VPWR VPWR sky130_fd_sc_hd__fill_1
XFILLER_29_73 VGND VGND VPWR VPWR sky130_fd_sc_hd__fill_2
Xhold84 net44 VGND VGND VPWR VPWR net275 sky130_fd_sc_hd__dlygate4sd3_1
Xhold73 net80 VGND VGND VPWR VPWR net264 sky130_fd_sc_hd__dlygate4sd3_1
Xhold62 net35 VGND VGND VPWR VPWR net253 sky130_fd_sc_hd__dlygate4sd3_1
Xhold95 net63 VGND VGND VPWR VPWR net286 sky130_fd_sc_hd__dlygate4sd3_1
XFILLER_43_163 VGND VGND VPWR VPWR sky130_fd_sc_hd__decap_4
XTAP_TAPCELL_ROW_41_331 VGND VPWR sky130_fd_sc_hd__tapvpwrvgnd_1
X_1640_ net170 net132 net46 VGND VGND VPWR VPWR _0779_ sky130_fd_sc_hd__and3_4
X_1571_ _0587_ _0626_ _0557_ VGND VGND VPWR VPWR _0710_ sky130_fd_sc_hd__a21o_1
XFILLER_3_281 VPWR VGND VPWR VGND sky130_ef_sc_hd__decap_12
XANTENNA_4 net157 VGND VGND VPWR VPWR sky130_fd_sc_hd__diode_2
X_2123_ _0087_ _0090_ _0137_ VGND VGND VPWR VPWR _0138_ sky130_fd_sc_hd__a21o_1
Xrebuffer27 _1003_ VGND VGND VPWR VPWR net218 sky130_fd_sc_hd__buf_1
Xrebuffer16 _1004_ VGND VGND VPWR VPWR net207 sky130_fd_sc_hd__dlymetal6s2s_1
X_2054_ _0066_ _0067_ _0068_ VGND VGND VPWR VPWR _0069_ sky130_fd_sc_hd__nand3_2
XFILLER_41_19 VPWR VGND VPWR VGND sky130_ef_sc_hd__decap_12
X_1907_ _1034_ _1041_ VGND VGND VPWR VPWR _1046_ sky130_fd_sc_hd__xnor2_2
X_1838_ _0970_ _0971_ _0976_ VGND VGND VPWR VPWR _0977_ sky130_fd_sc_hd__nand3_1
X_1769_ net147 net117 net189 net151 VGND VGND VPWR VPWR _0908_ sky130_fd_sc_hd__a22oi_1
XFILLER_40_133 VGND VGND VPWR VPWR sky130_fd_sc_hd__fill_2
XFILLER_15_53 VGND VGND VPWR VPWR sky130_fd_sc_hd__decap_3
Xoutput30 net30 VGND VGND VPWR VPWR a_out[11] sky130_fd_sc_hd__buf_2
Xoutput52 net52 VGND VGND VPWR VPWR acc_out[17] sky130_fd_sc_hd__buf_2
XFILLER_31_85 VGND VGND VPWR VPWR sky130_fd_sc_hd__fill_1
XFILLER_31_41 VGND VGND VPWR VPWR sky130_fd_sc_hd__fill_1
XFILLER_31_30 VGND VGND VPWR VPWR sky130_fd_sc_hd__fill_2
Xoutput41 net41 VGND VGND VPWR VPWR a_out[7] sky130_fd_sc_hd__buf_2
XFILLER_48_277 VPWR VGND VPWR VGND sky130_ef_sc_hd__decap_12
XFILLER_48_233 VPWR VGND VPWR VGND sky130_ef_sc_hd__decap_12
Xoutput74 net74 VGND VGND VPWR VPWR acc_out[8] sky130_fd_sc_hd__buf_2
Xoutput63 net63 VGND VGND VPWR VPWR acc_out[27] sky130_fd_sc_hd__buf_2
XFILLER_31_111 VGND VGND VPWR VPWR sky130_fd_sc_hd__fill_1
X_1554_ _0686_ _0691_ VGND VGND VPWR VPWR _0693_ sky130_fd_sc_hd__xnor2_1
X_1623_ net152 net183 _0745_ _0744_ VGND VGND VPWR VPWR _0762_ sky130_fd_sc_hd__a31o_1
X_1485_ _0530_ _0558_ _0584_ _0586_ VGND VGND VPWR VPWR _0624_ sky130_fd_sc_hd__a211o_1
.ends
